# Ansys Electronics Desktop project, version 2024.2
materials:
  vacuum: permittivity=1
  RO4003: permittivity=3.38 dielectric_loss_tangent=0.0027
  copper: permeability=0.999991 conductivity=58000000
  perfect conductor: conductivity=1e+30
  air: permittivity=1.0006 permeability=1.0000004
  Rogers RT/duroid 6010/6010LM (tm): permittivity=10.8 dielectric_loss_tangent=0.0023
  Rogers RO4003 (tm): permittivity=3.55 dielectric_loss_tangent=0.0027

design HFSSDesign13 BPF-design (HFSS, HFSS Modal Network, model units mm)
options: Save_Adaptive_support_files
geometry:
  Substrate_1 [Rogers RO4003 (tm)] = box(corner=(-36mm, -31.62mm, 0.035mm), size=(72mm, 63.24mm, 0.813mm))
  air_box [air] = box(corner=(-39mm, -31.62mm, -23mm), size=(78mm, 63.24mm, 46mm))
  Substrate_2 [Rogers RO4003 (tm)] = box(corner=(-36mm, -31.62mm, -0.035mm), size=(72mm, 63.24mm, -0.813mm))
  Substrate_3 [copper] = box(corner=(-1.82mm, 0mm, 0.848mm), size=(3.64mm, 20.63mm, 0.035mm))
  Substrate_4 = box(corner=(-0.9mm, 0mm, 0.848mm), size=(1.8mm, -31.62mm, 0.035mm))
  Substrate_3.unite(Substrate_4)
  Substrate_5 [copper] = box(corner=(-24.94mm, -21.6mm, -0.848mm), size=(2.69mm, 43.2mm, -0.035mm))
  Substrate_7 [copper] = box(corner=(-36mm, -31.62mm, 0mm), size=(72mm, 63.24mm, 0.035mm))
  Substrate_9 [copper] = box(corner=(-36mm, -31.62mm, 0mm), size=(72mm, 63.24mm, -0.035mm))
  Rectangle1 = rectangle(corner=(-31.115mm, -31.62mm, 0mm), z_size=6.504mm, x_size=15.04mm)
  Substrate_10 = box(corner=(-4.65mm, -0.75mm, 0mm), size=(9.3mm, 1.5mm, 0.035mm))
  Substrate_12 = box(corner=(-4.65mm, -0.75mm, 0mm), size=(9.3mm, 1.5mm, -0.035mm))
  Substrate_13 = box(corner=(-5.15mm, -11.87mm, 0mm), size=(0.5mm, 23.74mm, 0.035mm))
  Substrate_14 = box(corner=(-5.15mm, -11.87mm, 0mm), size=(0.5mm, 23.74mm, -0.035mm))
  Substrate_15 = box(corner=(-6.82mm, -11.87mm, 0mm), size=(1.67mm, 0.5mm, 0.035mm))
  Substrate_16 = box(corner=(-6.82mm, -11.87mm, 0mm), size=(1.67mm, 0.5mm, -0.035mm))
  Substrate_17 = box(corner=(-7.32mm, -11.87mm, 0mm), size=(0.5mm, 9.62mm, 0.035mm))
  Substrate_18 = box(corner=(-7.32mm, -11.87mm, 0mm), size=(0.5mm, 9.62mm, -0.035mm))
  Substrate_19 = box(corner=(-6.82mm, 11.87mm, 0mm), size=(1.67mm, -0.5mm, 0.035mm))
  Substrate_20 = box(corner=(-6.82mm, 11.87mm, 0mm), size=(1.67mm, -0.5mm, -0.035mm))
  Substrate_21 = box(corner=(-7.32mm, 11.87mm, 0mm), size=(0.5mm, -9.62mm, 0.035mm))
  Substrate_22 = box(corner=(-7.32mm, 11.87mm, 0mm), size=(0.5mm, -9.62mm, -0.035mm))
  Substrate_13.unite(Substrate_15, Substrate_17, Substrate_19, Substrate_21, Substrate_10)
  Substrate_23 = box(corner=(5.15mm, -11.87mm, 0mm), size=(-0.5mm, 23.74mm, 0.035mm))
  Substrate_24 = box(corner=(6.82mm, -11.87mm, 0mm), size=(-1.67mm, 0.5mm, 0.035mm))
  Substrate_25 = box(corner=(7.32mm, -11.87mm, 0mm), size=(-0.5mm, 9.62mm, 0.035mm))
  Substrate_26 = box(corner=(6.82mm, 11.87mm, 0mm), size=(-1.67mm, -0.5mm, 0.035mm))
  Substrate_27 = box(corner=(7.32mm, 11.87mm, 0mm), size=(-0.5mm, -9.62mm, 0.035mm))
  Substrate_28 = box(corner=(5.15mm, -11.87mm, 0mm), size=(-0.5mm, 23.74mm, -0.035mm))
  Substrate_29 = box(corner=(6.82mm, -11.87mm, 0mm), size=(-1.67mm, 0.5mm, -0.035mm))
  Substrate_30 = box(corner=(7.32mm, -11.87mm, 0mm), size=(-0.5mm, 9.62mm, -0.035mm))
  Substrate_31 = box(corner=(6.82mm, 11.87mm, 0mm), size=(-1.67mm, -0.5mm, -0.035mm))
  Substrate_32 = box(corner=(7.32mm, 11.87mm, 0mm), size=(-0.5mm, -9.62mm, -0.035mm))
  Substrate_14.unite(Substrate_16, Substrate_18, Substrate_20, Substrate_22, Substrate_12)
  Substrate_13.unite(Substrate_23..Substrate_27)
  Substrate_28.unite(Substrate_29..Substrate_32)
  Substrate_14.unite(Substrate_28)
  Substrate_33 [copper] = box(corner=(-22.25mm, -21.6mm, -0.848mm), size=(44.5mm, 1.24mm, -0.035mm))
  Substrate_34 [copper] = box(corner=(24.94mm, -21.6mm, -0.848mm), size=(-2.69mm, 43.2mm, -0.035mm))
  Substrate_35 [copper] = box(corner=(-22.25mm, 21.6mm, -0.848mm), size=(44.5mm, -1.24mm, -0.035mm))
  Substrate_36 = box(corner=(-5.15mm, -11.87mm, 0mm), size=(0.5mm, 23.74mm, 0.035mm))
  Substrate_40 = box(corner=(-6.82mm, -11.87mm, 0mm), size=(1.67mm, 0.5mm, 0.035mm))
  Substrate_42 = box(corner=(-7.32mm, -11.87mm, 0mm), size=(0.5mm, 9.62mm, 0.035mm))
  Substrate_44 = box(corner=(-6.82mm, 11.87mm, 0mm), size=(1.67mm, -0.5mm, 0.035mm))
  Substrate_46 = box(corner=(-7.32mm, 11.87mm, 0mm), size=(0.5mm, -9.62mm, 0.035mm))
  Substrate_38 = box(corner=(-4.65mm, -0.75mm, 0mm), size=(9.3mm, 1.5mm, 0.035mm))
  Substrate_36.unite(Substrate_40, Substrate_42, Substrate_44, Substrate_46, Substrate_38)
  Substrate_48 = box(corner=(5.15mm, -11.87mm, 0mm), size=(-0.5mm, 23.74mm, 0.035mm))
  Substrate_49 = box(corner=(6.82mm, -11.87mm, 0mm), size=(-1.67mm, 0.5mm, 0.035mm))
  Substrate_50 = box(corner=(7.32mm, -11.87mm, 0mm), size=(-0.5mm, 9.62mm, 0.035mm))
  Substrate_51 = box(corner=(6.82mm, 11.87mm, 0mm), size=(-1.67mm, -0.5mm, 0.035mm))
  Substrate_52 = box(corner=(7.32mm, 11.87mm, 0mm), size=(-0.5mm, -9.62mm, 0.035mm))
  Substrate_36.unite(Substrate_48..Substrate_52)
  Substrate_37 = box(corner=(-5.15mm, -11.87mm, 0mm), size=(0.5mm, 23.74mm, -0.035mm))
  Substrate_41 = box(corner=(-6.82mm, -11.87mm, 0mm), size=(1.67mm, 0.5mm, -0.035mm))
  Substrate_43 = box(corner=(-7.32mm, -11.87mm, 0mm), size=(0.5mm, 9.62mm, -0.035mm))
  Substrate_45 = box(corner=(-6.82mm, 11.87mm, 0mm), size=(1.67mm, -0.5mm, -0.035mm))
  Substrate_47 = box(corner=(-7.32mm, 11.87mm, 0mm), size=(0.5mm, -9.62mm, -0.035mm))
  Substrate_39 = box(corner=(-4.65mm, -0.75mm, 0mm), size=(9.3mm, 1.5mm, -0.035mm))
  Substrate_37.unite(Substrate_41, Substrate_43, Substrate_45, Substrate_47, Substrate_39)
  Substrate_53 = box(corner=(5.15mm, -11.87mm, 0mm), size=(-0.5mm, 23.74mm, -0.035mm))
  Substrate_54 = box(corner=(6.82mm, -11.87mm, 0mm), size=(-1.67mm, 0.5mm, -0.035mm))
  Substrate_55 = box(corner=(7.32mm, -11.87mm, 0mm), size=(-0.5mm, 9.62mm, -0.035mm))
  Substrate_56 = box(corner=(6.82mm, 11.87mm, 0mm), size=(-1.67mm, -0.5mm, -0.035mm))
  Substrate_57 = box(corner=(7.32mm, 11.87mm, 0mm), size=(-0.5mm, -9.62mm, -0.035mm))
  Substrate_53.unite(Substrate_54..Substrate_57)
  Substrate_37.unite(Substrate_53)
  [Substrate_13, Substrate_14].move(-23.595mm, 0mm, 0mm)
  [Substrate_36, Substrate_37].move(23.595mm, 0mm, 0mm)
  Substrate_3.move(-23.595mm, 0mm, 0mm)
  Substrate_58 [copper] = box(corner=(-1.82mm, 0mm, 0.848mm), size=(3.64mm, -20.63mm, 0.035mm))
  Substrate_59 = box(corner=(-0.9mm, 0mm, 0.848mm), size=(1.8mm, 31.62mm, 0.035mm))
  Substrate_58.unite(Substrate_59)
  Rectangle2 = rectangle(corner=(31.115mm, 31.62mm, 0mm), z_size=6.504mm, x_size=-15.04mm)
  Substrate_58.move(23.595mm, 0mm, 0mm)
  Substrate_7.subtract(Substrate_13, Substrate_36)
  Substrate_9.subtract(Substrate_14, Substrate_37)
boundaries and excitations:
  Rad1: Radiation Objects=air_box
  1: Wave Port Objects=Rectangle1 WavePortType=Modal NumModes=1 Modes{Mode1{IntLine{(-23.595, -31.62, 0) -> (-23.595, -31.62, 6.504)} CharImp=Zpi}}
  2: Wave Port Objects=Rectangle2 WavePortType=Modal NumModes=1 Modes{Mode1{IntLine{(23.595, 31.62, 0) -> (23.595, 31.62, 6.504)} CharImp=Zpi}}
setups:
  Setup12: HfssDriven Frequency=2.1GHz MaxDeltaS=0.01 MaximumPasses=20 MinimumPasses=2 MinimumConvergedPasses=2 PercentRefinement=30 BasisOrder=1 PortAccuracy=2 DrivenSolverType="Direct Solver"
    sweep Sweep: 0.1GHz to 5GHz step 0.01GHz; Type=Interpolating InterpTolerance=0.5 InterpMaxSolns=250 InterpUsePortImped=false
source amplitudes:
  1:1: 1W 0deg
  2:1: 0W 0deg
output variables:
  sdd21 = arg((S(2,1)-S(3,1)-S(2,4)+S(3,4))/2)
  sdd11 = mag((S(1,1)-S(4,1)-S(1,4)+S(4,4))/2)
  scc21 = arg((S(2,1)+S(3,1)+S(2,4)+S(3,4))/2)
  scc11 = mag((S(1,1)+S(4,1)+S(1,4)+S(4,4))/2)
  scd21 = mag((S(2,1)-S(2,4)+S(3,1)-S(3,4))/2)
  scd11 = mag((S(1,1)-S(1,4)+S(4,1)-S(4,4))/2)
  sdc11 = mag((S(1,1)+S(1,4)-S(4,1)-S(4,4))/2)
  sdc21 = mag((S(2,1)+S(2,4)-S(3,1)-S(3,2))/2)
reports:
  XY Plot 12: dB(S(1,1)), dB(S(2,1)) vs Freq on Setup12 : Sweep; markers m1 at 3.38GHz, m2 at 0.67GHz, m3 at 2.07GHz, m4 at 2.87GHz, m5 at 1.42GHz, m6 at 0.99GHz

design HFSSDesign13 0.6 and 2.51_8 (HFSS, HFSS Modal Network, model units mm)
options: Save_Adaptive_support_files
geometry:
  Substrate_1 [Rogers RO4003 (tm)] = box(corner=(-31.464mm, -35mm, 0.035mm), size=(62.928mm, 70mm, 0.813mm))
  air_box [air] = box(corner=(-31.464mm, -35mm, -23mm), size=((31.464*2) mm, 70mm, 46mm))
  Substrate_2 [Rogers RO4003 (tm)] = box(corner=(-31.464mm, -35mm, -0.035mm), size=(62.928mm, 70mm, -0.813mm))
  Substrate_3 = box(corner=(-0.51mm, 0mm, 0.848mm), size=(0.96mm, 21.9mm, 0.035mm))
  Substrate_4 [copper] = box(corner=(-0.91mm, 0mm, 0.848mm), size=(1.82mm, -35mm, 0.035mm))
  Substrate_5 [copper] = box(corner=(-0.91mm, 0mm, -0.848mm), size=(1.82mm, 35mm, -0.035mm))
  Substrate_7 [copper] = box(corner=(-31.464mm, -35mm, 0mm), size=(62.928mm, 70mm, 0.035mm))
  Substrate_9 [copper] = box(corner=(-31.464mm, -35mm, 0mm), size=(62.928mm, 70mm, -0.035mm))
  Rectangle1 = rectangle(corner=(-7.52mm, -35mm, 0mm), z_size=6.504mm, x_size=15.04mm)
  Substrate_10 = box(corner=(-26.2mm, -0.34mm, 0mm), size=(52.4mm, 0.68mm, 0.035mm))
  Substrate_12 = box(corner=(-26.2mm, -0.34mm, 0mm), size=(52.4mm, 0.68mm, -0.035mm))
  Substrate_7.subtract(Substrate_10)
  Substrate_9.subtract(Substrate_12)
  Substrate_14 [copper] = box(corner=(-1.3mm, (21.9+0.635) mm, 0.848mm), size=(2.6mm, 1.2mm, 0.035mm))
  Cylinder1 [copper] = cylinder(axis=Z, base_centre=(0mm, (21.9+1.3) mm, 0.848mm), radius=0.35mm, height=-0.813mm)
  Rectangle2 = rectangle(corner=(-7.52mm, 35mm, 0mm), z_size=-6.504mm, x_size=15.04mm)
  Polyline5 = polyline(z=0.883mm, xy: (0.45mm, 21.9mm) (-0.51mm, 21.9mm) (-0.51mm, (21.9+0.635) mm) (0.45mm, (21.9+0.635) mm) (0.45mm, 21.9mm), closed, covered)
  Cylinder2 [copper] = cylinder(axis=Z, base_centre=(0.8mm, (21.9+1.3) mm, 0.848mm), radius=0.35mm, height=-0.813mm)
  Cylinder3 [copper] = cylinder(axis=Z, base_centre=(-0.8mm, (21.9+1.3) mm, 0.848mm), radius=0.35mm, height=-0.813mm)
  Substrate_17 = box(corner=(-1.26mm, 0mm, 0.848mm), size=(2.52mm, 21.4mm, 0.035mm))
  Substrate_18 = box(corner=(-0.51mm, 0mm, -0.848mm), size=(0.96mm, -21.9mm, -0.035mm))
  Substrate_19 [copper] = box(corner=(-1.3mm, (-21.9-0.635) mm, -0.848mm), size=(2.6mm, -1.2mm, -0.035mm))
  Cylinder7 [copper] = cylinder(axis=Z, base_centre=(0mm, (-21.9-1.3) mm, -0.848mm), radius=0.35mm, height=0.813mm)
  Polyline12 = polyline(z=-0.883mm, xy: (0.51mm, -21.9mm) (-0.45mm, -21.9mm) (-0.45mm, (-21.9-0.635) mm) (0.51mm, (-21.9-0.635) mm) (0.51mm, -21.9mm), closed, covered)
  Cylinder8 [copper] = cylinder(axis=Z, base_centre=(0.8mm, (-21.9-1.3) mm, -0.848mm), radius=0.35mm, height=0.813mm)
  Cylinder9 [copper] = cylinder(axis=Z, base_centre=(-0.8mm, (-21.9-1.3) mm, -0.848mm), radius=0.35mm, height=0.813mm)
  Substrate_20 = box(corner=(-1.26mm, 0mm, -0.848mm), size=(2.52mm, -21.4mm, -0.035mm))
  [Substrate_3, Cylinder1, Cylinder2, Cylinder3, Polyline5, Substrate_14].rotate(axis=Z, angle=55deg)
  [Substrate_3, Cylinder1, Cylinder2, Cylinder3, Polyline5, Substrate_14].move(-0.61747602mm, 0.41776754mm, 1.110223e-16mm)
  Substrate_17.rotate(axis=Z, angle=-45deg)
  Substrate_17.move(0.019045456mm, 0.89095454mm, 0mm)
  Cylinder10 = cylinder(axis=Z, base_centre=(0mm, (21.9+1.3) mm, 0.848mm), radius=0.35mm, height=-0.813mm)
  Cylinder10.rotate(axis=Z, angle=55deg)
  Cylinder10.move(-0.61747602mm, 0.41776754mm, 1.110223e-16mm)
  Cylinder11 = cylinder(axis=Z, base_centre=(0.8mm, (21.9+1.3) mm, 0.848mm), radius=0.35mm, height=-0.813mm)
  Cylinder11.rotate(axis=Z, angle=55deg)
  Cylinder11.move(-0.61747602mm, 0.41776754mm, 1.110223e-16mm)
  Cylinder12 = cylinder(axis=Z, base_centre=(-0.8mm, (21.9+1.3) mm, 0.848mm), radius=0.35mm, height=-0.813mm)
  Cylinder12.rotate(axis=Z, angle=55deg)
  Cylinder12.move(-0.61747602mm, 0.41776754mm, 1.110223e-16mm)
  Substrate_1.subtract(Cylinder10, Cylinder11, Cylinder12)
  [Substrate_18, Substrate_19, Polyline12, Cylinder7, Cylinder8, Cylinder9].rotate(axis=Z, angle=55deg)
  [Substrate_18, Substrate_19, Polyline12, Cylinder7, Cylinder8, Cylinder9].move(0.61747602mm, -0.41776754mm, 0mm)
  Polyline13 = polyline(z=0.883mm, xy in mm: (-0.91, 0) (0.91, 0) (-0.1891632, 0.81476287) (-0.91, 0), closed, covered)
  Polyline15 = polyline(z=0.883mm, xy in mm: (-0.1891632, 1.0991632) (-0.87190909, 1.7819091) (-0.1891632, 2.464655) (-0.1891632, 1.0991632), closed, covered)
  Polyline15.sweep_along_vector((0mm, 0mm, -0.035mm))
  Polyline16 = polyline(z=0.883mm, xy in mm: (-0.1891632, 0.81476287) (-0.1891632, 2.5) (0.91, 2.5) (0.91, 0) (-0.1891632, 0.81476287), closed, covered)
  [Polyline13, Polyline16].sweep_along_vector((0mm, 0mm, -0.035mm))
  Polyline18 = polyline(z=-0.883mm, xy in mm: (0.91, 0) (0.1891632, -0.81476287) (-0.91, 0) (0.91, 0), closed, covered)
  Polyline19 = polyline(z=-0.883mm, xy in mm: (-0.91, 0) (0.1891632, -0.81476287) (0.1891632, -2.5) (-0.91, -2.5) (-0.91, 0), closed, covered)
  [Polyline19, Polyline18].sweep_along_vector((0mm, 0mm, 0.035mm))
  Cylinder13 = cylinder(axis=Z, base_centre=(0mm, (-21.9-1.3) mm, -0.848mm), radius=0.35mm, height=0.813mm)
  Cylinder13.rotate(axis=Z, angle=55deg)
  Cylinder13.move(0.61747602mm, -0.41776754mm, 0mm)
  Cylinder14 = cylinder(axis=Z, base_centre=(0.8mm, (-21.9-1.3) mm, -0.848mm), radius=0.35mm, height=0.813mm)
  Cylinder14.rotate(axis=Z, angle=55deg)
  Cylinder14.move(0.61747602mm, -0.41776754mm, 0mm)
  Cylinder15 = cylinder(axis=Z, base_centre=(-0.8mm, (-21.9-1.3) mm, -0.848mm), radius=0.35mm, height=0.813mm)
  Cylinder15.rotate(axis=Z, angle=55deg)
  Cylinder15.move(0.61747602mm, -0.41776754mm, 0mm)
  Substrate_2.subtract(Cylinder13, Cylinder14, Cylinder15)
  Substrate_17.subtract(Polyline16)
  Substrate_17.subtract(Polyline15)
  Polyline24 = polyline(z=0.883mm, xy in mm: (0.91, 0) (0.91, 2.5) (-0.15381818, 2.5) (-0.1891632, 0.81476287) (0.91, 0), closed, covered)
  Polyline24.sweep_along_vector((0mm, 0mm, -0.035mm))
  Substrate_20.rotate(axis=Z, angle=-45deg)
  Substrate_20.move(-0.019045456mm, -0.89095454mm, 0mm)
  Substrate_20.subtract(Polyline19)
  Polyline25 = polyline(z=-0.883mm, xy in mm: (0.1891632, -2.464655) (0.1891632, -1.0991632) (0.87190909, -1.7819091) (0.1891632, -2.464655), closed, covered)
  Polyline25.sweep_along_vector((0mm, 0mm, 0.035mm))
  Substrate_20.subtract(Polyline25)
  Polyline26 = polyline(z=-0.883mm, xy in mm: (-0.91, 0) (-0.91, -2.5) (0.15381818, -2.5) (0.1891632, -0.81476287) (-0.91, 0), closed, covered)
  Polyline26.sweep_along_vector((0mm, 0mm, 0.035mm))
  Substrate_18.move(0.034414586mm, 0.049149123mm, -1.110223e-16mm)
  Polyline27 = polyline(z=-0.883mm, xy in mm: (0.1891632, -0.81476287) (0.35936662, -0.78638596) (0.91, 0) (0.1891632, -0.81476287), closed, covered)
  Polyline27.sweep_along_vector((0mm, 0mm, 0.035mm))
  Polyline28 = polyline(z=0.883mm, xy in mm: (-0.35936662, 0.78638596) (-0.1891632, 0.81476287) (-0.91, 0) (-0.35936662, 0.78638596), closed, covered)
  Polyline28.sweep_along_vector((0mm, 0mm, -0.035mm))
  Polyline29 = polyline(z=0.883mm, xy in mm: (-0.1891632, 0.81476287) (-0.35936662, 0.78638596) (-18.298796, 13.34771) (-0.1891632, 0.81476287), closed, covered)
  Polyline29.sweep_along_vector((0mm, 0mm, -0.035mm))
  Polyline30 = polyline(z=-0.883mm, xy in mm: (0.1891632, -0.81476287) (0.35936662, -0.78638596) (18.298796, -13.34771) (0.1891632, -0.81476287), closed, covered)
  Polyline30.sweep_along_vector((0mm, 0mm, 0.035mm))
  Substrate_4.unite(Polyline13, Polyline24, Polyline28, Substrate_17, Polyline29, Substrate_3)
  Substrate_5.unite(Substrate_20, Polyline18, Polyline26, Polyline27, Polyline30, Substrate_18)
boundaries and excitations:
  Rad1: Radiation Objects=air_box
  LumpRLC1: Lumped RLC Objects=Polyline5 CurrentLine{(-18.574113, 12.954517, 0.883) -> (-19.094275, 13.318738, 0.883)} RLC_Type=Parallel Resistance=50ohm
  LumpRLC2: Lumped RLC Objects=Polyline12 CurrentLine{(18.574113, -12.954517, -0.883) -> (19.094275, -13.318738, -0.883)} RLC_Type=Parallel Resistance=50ohm
  1: Wave Port Objects=Rectangle1 WavePortType=Modal NumModes=1 Modes{Mode1{IntLine{(0, -35, 0.883) -> (0, -35, 0)} CharImp=Zpi}}
  2: Wave Port Objects=Rectangle2 WavePortType=Modal NumModes=1 Modes{Mode1{IntLine{(0, 35, -0.883) -> (0, 35, 0)} CharImp=Zpi}}
setups:
  Setup18: HfssDriven Frequency=4GHz MaxDeltaS=0.005 MaximumPasses=30 MinimumPasses=6 MinimumConvergedPasses=2 PercentRefinement=30 BasisOrder=1 PortAccuracy=2 DrivenSolverType="Direct Solver"
    sweep Sweep: 0.01GHz to 5GHz step 0.01GHz; Type=Fast
  Setup19: HfssDriven Frequency=4GHz MaxDeltaS=0.005 MaximumPasses=30 MinimumPasses=6 MinimumConvergedPasses=2 PercentRefinement=30 BasisOrder=1 PortAccuracy=2 DrivenSolverType="Direct Solver"
    sweep Sweep: 0.01GHz to 5GHz step 0.01GHz; Type=Interpolating InterpTolerance=0.5 InterpMaxSolns=250 InterpUsePortImped=false PassivityErrorTolerance=0.0001
  Setup20: HfssDriven MultipleAdaptiveFreqsSetup{Low=0.1GHz High=5GHz} MaxDeltaS=0.005 MaximumPasses=30 MinimumPasses=6 MinimumConvergedPasses=2 PercentRefinement=30 BasisOrder=1 PortAccuracy=2 DrivenSolverType="Direct Solver"
    sweep Sweep: 0.01GHz to 5GHz step 0.01GHz; Type=Fast
  Setup21: HfssDriven Frequency=5GHz MaxDeltaS=0.005 MaximumPasses=30 MinimumPasses=6 MinimumConvergedPasses=2 PercentRefinement=30 BasisOrder=1 PortAccuracy=2 DrivenSolverType="Direct Solver"
    sweep Sweep: 0.01GHz to 5GHz step 0.01GHz; Type=Fast
source amplitudes:
  1:1: 1W 0deg
  2:1: 0W 0deg
output variables:
  sdd21 = arg((S(2,1)-S(3,1)-S(2,4)+S(3,4))/2)
  sdd11 = mag((S(1,1)-S(4,1)-S(1,4)+S(4,4))/2)
  scc21 = arg((S(2,1)+S(3,1)+S(2,4)+S(3,4))/2)
  scc11 = mag((S(1,1)+S(4,1)+S(1,4)+S(4,4))/2)
  scd21 = mag((S(2,1)-S(2,4)+S(3,1)-S(3,4))/2)
  scd11 = mag((S(1,1)-S(1,4)+S(4,1)-S(4,4))/2)
  sdc11 = mag((S(1,1)+S(1,4)-S(4,1)-S(4,4))/2)
  sdc21 = mag((S(2,1)+S(2,4)-S(3,1)-S(3,2))/2)
reports:
  XY Plot 20: dB(S(1,1)), dB(S(1,2)), dB(S(2,1)), dB(S(2,2)) vs Freq on Setup18 : Sweep; markers m1 at 2.6GHz, m2 at 1.13GHz, m3 at 0.01GHz, m4 at 0.01GHz
  S Parameter Plot 1: dB(S(1,1)), dB(S(2,1)) vs Freq on Setup19 : Sweep; markers m1 at 2.59GHz
  S Parameter Plot 2: dB(S(1,1)), dB(S(2,1)) vs Freq on Setup20 : Sweep; markers m1 at 2.6GHz
  S Parameter Plot 3: dB(S(2,1)) vs Freq on Setup18 : Sweep; dB(S(1,1)) vs Freq on Setup21 : Sweep; markers m1 at 2.6GHz

design HFSSDesign13 0.6 and 2.51_Fabrication (HFSS, HFSS Modal Network, model units mm)
options: Save_Adaptive_support_files
geometry:
  Substrate_1 [Rogers RO4003 (tm)] = box(corner=(-35mm, -35mm, 0.035mm), size=(70mm, 70mm, 0.813mm))
  Substrate_3 [copper] = box(corner=(-0.51mm, 0mm, 0.848mm), size=(0.96mm, 21.9mm, 0.035mm))
  Substrate_4 = box(corner=(-0.91mm, 0mm, 0.848mm), size=(1.82mm, -35mm, 0.035mm))
  Substrate_7 [copper] = box(corner=(-35mm, -35mm, 0mm), size=(70mm, 70mm, 0.035mm))
  Substrate_10 = box(corner=(-26.2mm, -0.34mm, 0mm), size=(52.4mm, 0.68mm, 0.035mm))
  Substrate_7.subtract(Substrate_10)
  Substrate_14 [copper] = box(corner=(-1.3mm, (21.9+0.635) mm, 0.848mm), size=(2.6mm, 1.2mm, 0.035mm))
  Cylinder1 = cylinder(axis=Z, base_centre=(0mm, (21.9+1.3) mm, 0.883mm), radius=0.35mm, height=-0.035mm)
  Cylinder2 = cylinder(axis=Z, base_centre=(0.8mm, (21.9+1.3) mm, 0.883mm), radius=0.35mm, height=-0.035mm)
  Cylinder3 = cylinder(axis=Z, base_centre=(-0.8mm, (21.9+1.3) mm, 0.883mm), radius=0.35mm, height=-0.035mm)
  Substrate_17 = box(corner=(-1.26mm, 0mm, 0.848mm), size=(2.52mm, 21.4mm, 0.035mm))
  [Substrate_3, Cylinder1, Cylinder2, Cylinder3, Substrate_14].rotate(axis=Z, angle=55deg)
  [Substrate_3, Cylinder1, Cylinder2, Cylinder3, Substrate_14].move(-0.61747602mm, 0.41776754mm, 1.110223e-16mm)
  Substrate_17.rotate(axis=Z, angle=-45deg)
  Substrate_17.move(0.019045456mm, 0.89095454mm, 0mm)
  Cylinder10 = cylinder(axis=Z, base_centre=(0mm, (21.9+1.3) mm, 0.848mm), radius=0.35mm, height=-0.813mm)
  Cylinder10.rotate(axis=Z, angle=55deg)
  Cylinder10.move(-0.61747602mm, 0.41776754mm, 1.110223e-16mm)
  Cylinder11 = cylinder(axis=Z, base_centre=(0.8mm, (21.9+1.3) mm, 0.848mm), radius=0.35mm, height=-0.813mm)
  Cylinder11.rotate(axis=Z, angle=55deg)
  Cylinder11.move(-0.61747602mm, 0.41776754mm, 1.110223e-16mm)
  Cylinder12 = cylinder(axis=Z, base_centre=(-0.8mm, (21.9+1.3) mm, 0.848mm), radius=0.35mm, height=-0.813mm)
  Cylinder12.rotate(axis=Z, angle=55deg)
  Cylinder12.move(-0.61747602mm, 0.41776754mm, 1.110223e-16mm)
  Substrate_1.subtract(Cylinder10, Cylinder11, Cylinder12)
  Polyline13 = polyline(z=0.883mm, xy in mm: (-0.91, 0) (0.91, 0) (-0.1891632, 0.81476287) (-0.91, 0), closed, covered)
  Polyline15 = polyline(z=0.883mm, xy in mm: (-0.1891632, 1.0991632) (-0.87190909, 1.7819091) (-0.1891632, 2.464655) (-0.1891632, 1.0991632), closed, covered)
  Polyline15.sweep_along_vector((0mm, 0mm, -0.035mm))
  Polyline16 = polyline(z=0.883mm, xy in mm: (-0.1891632, 0.81476287) (-0.1891632, 2.5) (0.91, 2.5) (0.91, 0) (-0.1891632, 0.81476287), closed, covered)
  [Polyline13, Polyline16].sweep_along_vector((0mm, 0mm, -0.035mm))
  Substrate_17.subtract(Polyline16)
  Substrate_17.subtract(Polyline15)
  Polyline24 = polyline(z=0.883mm, xy in mm: (0.91, 0) (0.91, 2.5) (-0.15381818, 2.5) (-0.1891632, 0.81476287) (0.91, 0), closed, covered)
  Polyline24.sweep_along_vector((0mm, 0mm, -0.035mm))
  Polyline28 = polyline(z=0.883mm, xy in mm: (-0.35936662, 0.78638596) (-0.1891632, 0.81476287) (-0.91, 0) (-0.35936662, 0.78638596), closed, covered)
  Polyline28.sweep_along_vector((0mm, 0mm, -0.035mm))
  Polyline29 = polyline(z=0.883mm, xy in mm: (-0.1891632, 0.81476287) (-0.35936662, 0.78638596) (-18.298796, 13.34771) (-0.1891632, 0.81476287), closed, covered)
  Polyline29.sweep_along_vector((0mm, 0mm, -0.035mm))
  Circle17 = circle(normal=Z, centre=(-26.464mm, -28mm, 0.883mm), radius=2mm)
  Circle19 = circle(normal=Z, centre=(-26.464mm, -28mm, 0.883mm), radius=1mm)
  Circle17.subtract(Circle19)
  Circle17.move(0mm, 0mm, 0.035mm)
  coordinate_system RelativeCS1 = origin=(0mm, 0mm, 0mm) x=(1mm, 0mm, 0mm) y=(0mm, 1mm, 0mm)
  coordinate_system RelativeCS2 = origin=(0mm, 0mm, 0.035mm) x=(1mm, 0mm, 0mm) y=(0mm, 1mm, 0mm) in RelativeCS1
  coordinate_system RelativeCS3 = origin=(0mm, 0mm, 0.813mm) x=(1mm, 0mm, 0mm) y=(0mm, 1mm, 0mm) in RelativeCS2
  coordinate_system RelativeCS4 = origin=(0mm, 0mm, 0.035mm) x=(1mm, 0mm, 0mm) y=(0mm, 1mm, 0mm) in RelativeCS3
  coordinate_system RelativeCS5 = origin=(0mm, 0mm, -0.848mm) x=(1mm, 0mm, 0mm) y=(0mm, 1mm, 0mm) in RelativeCS4
  Circle48 = circle(normal=Z, centre=(-26.464mm, -28mm, 0.848mm), radius=1mm) in RelativeCS5
  Circle48.move(0mm, 0mm, -0.848mm) in RelativeCS5
  Circle49 = circle(normal=Z, centre=(-26.464mm, -15mm, 0.883mm), radius=2mm)
  Circle51 = circle(normal=Z, centre=(-26.464mm, -15mm, 0.883mm), radius=1mm)
  Circle49.subtract(Circle51)
  Circle49.move(0mm, 0mm, 0.035mm)
  coordinate_system RelativeCS6 = origin=(0mm, 0mm, 0mm) x=(1mm, 0mm, 0mm) y=(0mm, 1mm, 0mm)
  coordinate_system RelativeCS7 = origin=(0mm, 0mm, 0.035mm) x=(1mm, 0mm, 0mm) y=(0mm, 1mm, 0mm) in RelativeCS6
  coordinate_system RelativeCS8 = origin=(0mm, 0mm, 0.813mm) x=(1mm, 0mm, 0mm) y=(0mm, 1mm, 0mm) in RelativeCS7
  coordinate_system RelativeCS9 = origin=(0mm, 0mm, 0.035mm) x=(1mm, 0mm, 0mm) y=(0mm, 1mm, 0mm) in RelativeCS8
  coordinate_system RelativeCS10 = origin=(0mm, 0mm, -0.848mm) x=(1mm, 0mm, 0mm) y=(0mm, 1mm, 0mm) in RelativeCS9
  Circle50 = circle(normal=Z, centre=(-26.464mm, -15mm, 0.848mm), radius=1mm) in RelativeCS10
  Circle50.move(0mm, 0mm, -0.848mm) in RelativeCS10
  Circle52 = circle(normal=Z, centre=(-26.464mm, 28mm, 0.883mm), radius=2mm)
  Circle56 = circle(normal=Z, centre=(-26.464mm, 28mm, 0.883mm), radius=1mm)
  Circle52.subtract(Circle56)
  Circle52.move(0mm, 0mm, 0.035mm)
  coordinate_system RelativeCS11 = origin=(0mm, 0mm, 0mm) x=(1mm, 0mm, 0mm) y=(0mm, 1mm, 0mm)
  coordinate_system RelativeCS12 = origin=(0mm, 0mm, 0.035mm) x=(1mm, 0mm, 0mm) y=(0mm, 1mm, 0mm) in RelativeCS11
  coordinate_system RelativeCS13 = origin=(0mm, 0mm, 0.813mm) x=(1mm, 0mm, 0mm) y=(0mm, 1mm, 0mm) in RelativeCS12
  coordinate_system RelativeCS14 = origin=(0mm, 0mm, 0.035mm) x=(1mm, 0mm, 0mm) y=(0mm, 1mm, 0mm) in RelativeCS13
  coordinate_system RelativeCS15 = origin=(0mm, 0mm, -0.848mm) x=(1mm, 0mm, 0mm) y=(0mm, 1mm, 0mm) in RelativeCS14
  Circle53 = circle(normal=Z, centre=(-26.464mm, 28mm, 0.848mm), radius=1mm) in RelativeCS15
  Circle53.move(0mm, 0mm, -0.848mm) in RelativeCS15
  Circle54 = circle(normal=Z, centre=(-26.464mm, 15mm, 0.883mm), radius=2mm)
  Circle57 = circle(normal=Z, centre=(-26.464mm, 15mm, 0.883mm), radius=1mm)
  Circle54.subtract(Circle57)
  Circle54.move(0mm, 0mm, 0.035mm)
  coordinate_system RelativeCS16 = origin=(0mm, 0mm, 0mm) x=(1mm, 0mm, 0mm) y=(0mm, 1mm, 0mm)
  coordinate_system RelativeCS17 = origin=(0mm, 0mm, 0.035mm) x=(1mm, 0mm, 0mm) y=(0mm, 1mm, 0mm) in RelativeCS16
  coordinate_system RelativeCS18 = origin=(0mm, 0mm, 0.813mm) x=(1mm, 0mm, 0mm) y=(0mm, 1mm, 0mm) in RelativeCS17
  coordinate_system RelativeCS19 = origin=(0mm, 0mm, 0.035mm) x=(1mm, 0mm, 0mm) y=(0mm, 1mm, 0mm) in RelativeCS18
  coordinate_system RelativeCS20 = origin=(0mm, 0mm, -0.848mm) x=(1mm, 0mm, 0mm) y=(0mm, 1mm, 0mm) in RelativeCS19
  Circle55 = circle(normal=Z, centre=(-26.464mm, 15mm, 0.848mm), radius=1mm) in RelativeCS20
  Circle55.move(0mm, 0mm, -0.848mm) in RelativeCS20
  Circle58 = circle(normal=Z, centre=(26.464mm, -28mm, 0.883mm), radius=2mm)
  Circle66 = circle(normal=Z, centre=(26.464mm, -28mm, 0.883mm), radius=1mm)
  Circle58.subtract(Circle66)
  Circle58.move(0mm, 0mm, 0.035mm)
  coordinate_system RelativeCS21 = origin=(0mm, 0mm, 0mm) x=(1mm, 0mm, 0mm) y=(0mm, 1mm, 0mm)
  coordinate_system RelativeCS22 = origin=(0mm, 0mm, 0.035mm) x=(1mm, 0mm, 0mm) y=(0mm, 1mm, 0mm) in RelativeCS21
  coordinate_system RelativeCS23 = origin=(0mm, 0mm, 0.813mm) x=(1mm, 0mm, 0mm) y=(0mm, 1mm, 0mm) in RelativeCS22
  coordinate_system RelativeCS24 = origin=(0mm, 0mm, 0.035mm) x=(1mm, 0mm, 0mm) y=(0mm, 1mm, 0mm) in RelativeCS23
  coordinate_system RelativeCS25 = origin=(0mm, 0mm, -0.848mm) x=(1mm, 0mm, 0mm) y=(0mm, 1mm, 0mm) in RelativeCS24
  Circle59 = circle(normal=Z, centre=(26.464mm, -28mm, 0.848mm), radius=1mm) in RelativeCS25
  Circle59.move(0mm, 0mm, -0.848mm) in RelativeCS25
  Circle60 = circle(normal=Z, centre=(26.464mm, -15mm, 0.883mm), radius=2mm)
  Circle67 = circle(normal=Z, centre=(26.464mm, -15mm, 0.883mm), radius=1mm)
  Circle60.subtract(Circle67)
  Circle60.move(0mm, 0mm, 0.035mm)
  coordinate_system RelativeCS26 = origin=(0mm, 0mm, 0mm) x=(1mm, 0mm, 0mm) y=(0mm, 1mm, 0mm)
  coordinate_system RelativeCS27 = origin=(0mm, 0mm, 0.035mm) x=(1mm, 0mm, 0mm) y=(0mm, 1mm, 0mm) in RelativeCS26
  coordinate_system RelativeCS28 = origin=(0mm, 0mm, 0.813mm) x=(1mm, 0mm, 0mm) y=(0mm, 1mm, 0mm) in RelativeCS27
  coordinate_system RelativeCS29 = origin=(0mm, 0mm, 0.035mm) x=(1mm, 0mm, 0mm) y=(0mm, 1mm, 0mm) in RelativeCS28
  coordinate_system RelativeCS30 = origin=(0mm, 0mm, -0.848mm) x=(1mm, 0mm, 0mm) y=(0mm, 1mm, 0mm) in RelativeCS29
  Circle61 = circle(normal=Z, centre=(26.464mm, -15mm, 0.848mm), radius=1mm) in RelativeCS30
  Circle61.move(0mm, 0mm, -0.848mm) in RelativeCS30
  Circle62 = circle(normal=Z, centre=(26.464mm, 28mm, 0.883mm), radius=2mm)
  Circle68 = circle(normal=Z, centre=(26.464mm, 28mm, 0.883mm), radius=1mm)
  Circle62.subtract(Circle68)
  Circle62.move(0mm, 0mm, 0.035mm)
  coordinate_system RelativeCS31 = origin=(0mm, 0mm, 0mm) x=(1mm, 0mm, 0mm) y=(0mm, 1mm, 0mm)
  coordinate_system RelativeCS32 = origin=(0mm, 0mm, 0.035mm) x=(1mm, 0mm, 0mm) y=(0mm, 1mm, 0mm) in RelativeCS31
  coordinate_system RelativeCS33 = origin=(0mm, 0mm, 0.813mm) x=(1mm, 0mm, 0mm) y=(0mm, 1mm, 0mm) in RelativeCS32
  coordinate_system RelativeCS34 = origin=(0mm, 0mm, 0.035mm) x=(1mm, 0mm, 0mm) y=(0mm, 1mm, 0mm) in RelativeCS33
  coordinate_system RelativeCS35 = origin=(0mm, 0mm, -0.848mm) x=(1mm, 0mm, 0mm) y=(0mm, 1mm, 0mm) in RelativeCS34
  Circle63 = circle(normal=Z, centre=(26.464mm, 28mm, 0.848mm), radius=1mm) in RelativeCS35
  Circle63.move(0mm, 0mm, -0.848mm) in RelativeCS35
  Circle64 = circle(normal=Z, centre=(26.464mm, 15mm, 0.883mm), radius=2mm)
  Circle69 = circle(normal=Z, centre=(26.464mm, 15mm, 0.883mm), radius=1mm)
  Circle64.subtract(Circle69)
  Circle64.move(0mm, 0mm, 0.035mm)
  coordinate_system RelativeCS36 = origin=(0mm, 0mm, 0mm) x=(1mm, 0mm, 0mm) y=(0mm, 1mm, 0mm)
  coordinate_system RelativeCS37 = origin=(0mm, 0mm, 0.035mm) x=(1mm, 0mm, 0mm) y=(0mm, 1mm, 0mm) in RelativeCS36
  coordinate_system RelativeCS38 = origin=(0mm, 0mm, 0.813mm) x=(1mm, 0mm, 0mm) y=(0mm, 1mm, 0mm) in RelativeCS37
  coordinate_system RelativeCS39 = origin=(0mm, 0mm, 0.035mm) x=(1mm, 0mm, 0mm) y=(0mm, 1mm, 0mm) in RelativeCS38
  coordinate_system RelativeCS40 = origin=(0mm, 0mm, -0.848mm) x=(1mm, 0mm, 0mm) y=(0mm, 1mm, 0mm) in RelativeCS39
  Circle65 = circle(normal=Z, centre=(26.464mm, 15mm, 0.848mm), radius=1mm) in RelativeCS40
  Circle65.move(0mm, 0mm, -0.848mm) in RelativeCS40
  Substrate_3.unite(Substrate_4, Substrate_17, Polyline13, Polyline24, Polyline28, Polyline29)
  Cylinder16 = cylinder(axis=Z, base_centre=(0mm, (21.9+1.3) mm, 0.035mm), radius=0.35mm, height=-0.035mm)
  Cylinder16.rotate(axis=Z, angle=55deg)
  Cylinder16.move(-0.61747602mm, 0.41776754mm, 1.110223e-16mm)
  Cylinder17 = cylinder(axis=Z, base_centre=(0.8mm, (21.9+1.3) mm, 0.035mm), radius=0.35mm, height=-0.035mm)
  Cylinder17.rotate(axis=Z, angle=55deg)
  Cylinder17.move(-0.61747602mm, 0.41776754mm, 1.110223e-16mm)
  Cylinder18 = cylinder(axis=Z, base_centre=(-0.8mm, (21.9+1.3) mm, 0.035mm), radius=0.35mm, height=-0.035mm)
  Cylinder18.rotate(axis=Z, angle=55deg)
  Cylinder18.move(-0.61747602mm, 0.41776754mm, 1.110223e-16mm)
  Substrate_14.subtract(Cylinder1, Cylinder2, Cylinder3)
  Substrate_7.subtract(Cylinder16, Cylinder17, Cylinder18)
  Substrate_33 = box(corner=(-10mm, 35mm, 0.883mm), size=(20mm, -3mm, -0.035mm))
  Substrate_34 = box(corner=(-10mm, 35mm, 0mm), size=(20mm, -3mm, 0.035mm))
  Substrate_7.subtract(Substrate_34)
  coordinate_system RelativeCS41 = origin=(0mm, 0mm, 0.883mm) x=(1mm, 0mm, 0mm) y=(0mm, 1mm, 0mm)
  coordinate_system RelativeCS42 = origin=(0mm, 0mm, -0.883mm) x=(1mm, 0mm, 0mm) y=(0mm, 1mm, 0mm) in RelativeCS41
setups:
  Setup16: HfssDriven Frequency=3GHz MaxDeltaE=0.1 MaximumPasses=20 MinimumPasses=6 MinimumConvergedPasses=2 PercentRefinement=30 BasisOrder=1 DrivenSolverType="Direct Solver"
    sweep Sweep: 0.01GHz to 5GHz step 0.01GHz; Type=Discrete
  Setup18: HfssDriven Frequency=4GHz MaxDeltaE=0.1 MaximumPasses=20 MinimumPasses=6 MinimumConvergedPasses=2 PercentRefinement=30 BasisOrder=1 DrivenSolverType="Direct Solver"
    sweep Sweep: 0.01GHz to 5GHz step 0.01GHz; Type=Discrete
output variables:
  sdd21 = arg((S(2,1)-S(3,1)-S(2,4)+S(3,4))/2)
  sdd11 = mag((S(1,1)-S(4,1)-S(1,4)+S(4,4))/2)
  scc21 = arg((S(2,1)+S(3,1)+S(2,4)+S(3,4))/2)
  scc11 = mag((S(1,1)+S(4,1)+S(1,4)+S(4,4))/2)
  scd21 = mag((S(2,1)-S(2,4)+S(3,1)-S(3,4))/2)
  scd11 = mag((S(1,1)-S(1,4)+S(4,1)-S(4,4))/2)
  sdc11 = mag((S(1,1)+S(1,4)-S(4,1)-S(4,4))/2)
  sdc21 = mag((S(2,1)+S(2,4)-S(3,1)-S(3,2))/2)
reports:
  XY Plot 18: dB(S(1,1)), dB(S(1,2)), dB(S(2,1)), dB(S(2,2)) vs Freq on Setup16 : Sweep; markers m1 at 1.08GHz, m2 at 3.54GHz, m3 at 2.58GHz, m4 at 3.76GHz
  XY Plot 20: dB(S(1,1)), dB(S(1,2)), dB(S(2,1)), dB(S(2,2)) vs Freq on Setup18 : Sweep; markers m1 at 2.6GHz, m2 at 1.13GHz, m3 at 0.01GHz, m4 at 0.01GHz

design HFSSDesign13 0.6 and 2.51_Fabrication1 (HFSS, HFSS Modal Network, model units mm)
options: Save_Adaptive_support_files
geometry:
  Substrate_1 [Rogers RO4003 (tm)] = box(corner=(-35mm, -35mm, 0.035mm), size=(70mm, 70mm, 0.813mm))
  air_box [air] = box(corner=(-31.464mm, -35mm, -23mm), size=((31.464*2) mm, 70mm, 46mm))
  Substrate_2 [Rogers RO4003 (tm)] = box(corner=(-35mm, -35mm, -0.035mm), size=(70mm, 70mm, -0.813mm))
  Substrate_3 [copper] = box(corner=(-0.51mm, 0mm, 0.848mm), size=(0.96mm, 21.9mm, 0.035mm))
  Substrate_4 = box(corner=(-0.91mm, 0mm, 0.848mm), size=(1.82mm, -35mm, 0.035mm))
  Substrate_5 [copper] = box(corner=(-0.91mm, 0mm, -0.848mm), size=(1.82mm, 35mm, -0.035mm))
  Substrate_7 [copper] = box(corner=(-35mm, -35mm, 0mm), size=(70mm, 70mm, 0.035mm))
  Substrate_9 [copper] = box(corner=(-35mm, -35mm, 0mm), size=(70mm, 70mm, -0.035mm))
  Rectangle1 = rectangle(corner=(-7.52mm, -35mm, 0mm), z_size=6.504mm, x_size=15.04mm)
  Substrate_10 = box(corner=(-26.2mm, -0.34mm, 0mm), size=(52.4mm, 0.68mm, 0.035mm))
  Substrate_12 = box(corner=(-26.2mm, -0.34mm, 0mm), size=(52.4mm, 0.68mm, -0.035mm))
  Substrate_7.subtract(Substrate_10)
  Substrate_9.subtract(Substrate_12)
  Substrate_14 [copper] = box(corner=(-1.3mm, (21.9+0.635) mm, 0.848mm), size=(2.6mm, 1.2mm, 0.035mm))
  Cylinder1 = cylinder(axis=Z, base_centre=(0mm, (21.9+1.3) mm, 0.883mm), radius=0.35mm, height=-0.035mm)
  Rectangle2 = rectangle(corner=(-7.52mm, 35mm, 0mm), z_size=-6.504mm, x_size=15.04mm)
  Cylinder2 = cylinder(axis=Z, base_centre=(0.8mm, (21.9+1.3) mm, 0.883mm), radius=0.35mm, height=-0.035mm)
  Cylinder3 = cylinder(axis=Z, base_centre=(-0.8mm, (21.9+1.3) mm, 0.883mm), radius=0.35mm, height=-0.035mm)
  Substrate_17 = box(corner=(-1.26mm, 0mm, 0.848mm), size=(2.52mm, 21.4mm, 0.035mm))
  Substrate_18 = box(corner=(-0.51mm, 0mm, -0.848mm), size=(0.96mm, -21.9mm, -0.035mm))
  Substrate_19 [copper] = box(corner=(-1.3mm, (-21.9-0.635) mm, -0.848mm), size=(2.6mm, -1.2mm, -0.035mm))
  Cylinder7 [copper] = cylinder(axis=Z, base_centre=(0mm, (-21.9-1.3) mm, -0.848mm), radius=0.35mm, height=0.813mm)
  Cylinder8 [copper] = cylinder(axis=Z, base_centre=(0.8mm, (-21.9-1.3) mm, -0.848mm), radius=0.35mm, height=0.813mm)
  Cylinder9 [copper] = cylinder(axis=Z, base_centre=(-0.8mm, (-21.9-1.3) mm, -0.848mm), radius=0.35mm, height=0.813mm)
  Substrate_20 = box(corner=(-1.26mm, 0mm, -0.848mm), size=(2.52mm, -21.4mm, -0.035mm))
  [Substrate_3, Cylinder1, Cylinder2, Cylinder3, Substrate_14].rotate(axis=Z, angle=55deg)
  [Substrate_3, Cylinder1, Cylinder2, Cylinder3, Substrate_14].move(-0.61747602mm, 0.41776754mm, 1.110223e-16mm)
  Substrate_17.rotate(axis=Z, angle=-45deg)
  Substrate_17.move(0.019045456mm, 0.89095454mm, 0mm)
  Cylinder10 = cylinder(axis=Z, base_centre=(0mm, (21.9+1.3) mm, 0.848mm), radius=0.35mm, height=-0.813mm)
  Cylinder10.rotate(axis=Z, angle=55deg)
  Cylinder10.move(-0.61747602mm, 0.41776754mm, 1.110223e-16mm)
  Cylinder11 = cylinder(axis=Z, base_centre=(0.8mm, (21.9+1.3) mm, 0.848mm), radius=0.35mm, height=-0.813mm)
  Cylinder11.rotate(axis=Z, angle=55deg)
  Cylinder11.move(-0.61747602mm, 0.41776754mm, 1.110223e-16mm)
  Cylinder12 = cylinder(axis=Z, base_centre=(-0.8mm, (21.9+1.3) mm, 0.848mm), radius=0.35mm, height=-0.813mm)
  Cylinder12.rotate(axis=Z, angle=55deg)
  Cylinder12.move(-0.61747602mm, 0.41776754mm, 1.110223e-16mm)
  Substrate_1.subtract(Cylinder10, Cylinder11, Cylinder12)
  [Substrate_18, Substrate_19, Cylinder7, Cylinder8, Cylinder9].rotate(axis=Z, angle=55deg)
  [Substrate_18, Substrate_19, Cylinder7, Cylinder8, Cylinder9].move(0.61747602mm, -0.41776754mm, 0mm)
  Polyline13 = polyline(z=0.883mm, xy in mm: (-0.91, 0) (0.91, 0) (-0.1891632, 0.81476287) (-0.91, 0), closed, covered)
  Polyline15 = polyline(z=0.883mm, xy in mm: (-0.1891632, 1.0991632) (-0.87190909, 1.7819091) (-0.1891632, 2.464655) (-0.1891632, 1.0991632), closed, covered)
  Polyline15.sweep_along_vector((0mm, 0mm, -0.035mm))
  Polyline16 = polyline(z=0.883mm, xy in mm: (-0.1891632, 0.81476287) (-0.1891632, 2.5) (0.91, 2.5) (0.91, 0) (-0.1891632, 0.81476287), closed, covered)
  [Polyline13, Polyline16].sweep_along_vector((0mm, 0mm, -0.035mm))
  Polyline18 = polyline(z=-0.883mm, xy in mm: (0.91, 0) (0.1891632, -0.81476287) (-0.91, 0) (0.91, 0), closed, covered)
  Polyline19 = polyline(z=-0.883mm, xy in mm: (-0.91, 0) (0.1891632, -0.81476287) (0.1891632, -2.5) (-0.91, -2.5) (-0.91, 0), closed, covered)
  [Polyline19, Polyline18].sweep_along_vector((0mm, 0mm, 0.035mm))
  Cylinder13 = cylinder(axis=Z, base_centre=(0mm, (-21.9-1.3) mm, -0.848mm), radius=0.35mm, height=0.813mm)
  Cylinder13.rotate(axis=Z, angle=55deg)
  Cylinder13.move(0.61747602mm, -0.41776754mm, 0mm)
  Cylinder14 = cylinder(axis=Z, base_centre=(0.8mm, (-21.9-1.3) mm, -0.848mm), radius=0.35mm, height=0.813mm)
  Cylinder14.rotate(axis=Z, angle=55deg)
  Cylinder14.move(0.61747602mm, -0.41776754mm, 0mm)
  Cylinder15 = cylinder(axis=Z, base_centre=(-0.8mm, (-21.9-1.3) mm, -0.848mm), radius=0.35mm, height=0.813mm)
  Cylinder15.rotate(axis=Z, angle=55deg)
  Cylinder15.move(0.61747602mm, -0.41776754mm, 0mm)
  Substrate_2.subtract(Cylinder13, Cylinder14, Cylinder15)
  Substrate_17.subtract(Polyline16)
  Substrate_17.subtract(Polyline15)
  Polyline24 = polyline(z=0.883mm, xy in mm: (0.91, 0) (0.91, 2.5) (-0.15381818, 2.5) (-0.1891632, 0.81476287) (0.91, 0), closed, covered)
  Polyline24.sweep_along_vector((0mm, 0mm, -0.035mm))
  Substrate_20.rotate(axis=Z, angle=-45deg)
  Substrate_20.move(-0.019045456mm, -0.89095454mm, 0mm)
  Substrate_20.subtract(Polyline19)
  Polyline25 = polyline(z=-0.883mm, xy in mm: (0.1891632, -2.464655) (0.1891632, -1.0991632) (0.87190909, -1.7819091) (0.1891632, -2.464655), closed, covered)
  Polyline25.sweep_along_vector((0mm, 0mm, 0.035mm))
  Substrate_20.subtract(Polyline25)
  Polyline26 = polyline(z=-0.883mm, xy in mm: (-0.91, 0) (-0.91, -2.5) (0.15381818, -2.5) (0.1891632, -0.81476287) (-0.91, 0), closed, covered)
  Polyline26.sweep_along_vector((0mm, 0mm, 0.035mm))
  Substrate_18.move(0.034414586mm, 0.049149123mm, -1.110223e-16mm)
  Polyline27 = polyline(z=-0.883mm, xy in mm: (0.1891632, -0.81476287) (0.35936662, -0.78638596) (0.91, 0) (0.1891632, -0.81476287), closed, covered)
  Polyline27.sweep_along_vector((0mm, 0mm, 0.035mm))
  Polyline28 = polyline(z=0.883mm, xy in mm: (-0.35936662, 0.78638596) (-0.1891632, 0.81476287) (-0.91, 0) (-0.35936662, 0.78638596), closed, covered)
  Polyline28.sweep_along_vector((0mm, 0mm, -0.035mm))
  Polyline29 = polyline(z=0.883mm, xy in mm: (-0.1891632, 0.81476287) (-0.35936662, 0.78638596) (-18.298796, 13.34771) (-0.1891632, 0.81476287), closed, covered)
  Polyline29.sweep_along_vector((0mm, 0mm, -0.035mm))
  Polyline30 = polyline(z=-0.883mm, xy in mm: (0.1891632, -0.81476287) (0.35936662, -0.78638596) (18.298796, -13.34771) (0.1891632, -0.81476287), closed, covered)
  Polyline30.sweep_along_vector((0mm, 0mm, 0.035mm))
  Circle17 = circle(normal=Z, centre=(-26.464mm, -28mm, 0.883mm), radius=2mm)
  Circle19 = circle(normal=Z, centre=(-26.464mm, -28mm, 0.883mm), radius=1mm)
  Circle17.subtract(Circle19)
  Circle17.move(0mm, 0mm, 0.035mm)
  coordinate_system RelativeCS1 = origin=(0mm, 0mm, 0mm) x=(1mm, 0mm, 0mm) y=(0mm, 1mm, 0mm)
  coordinate_system RelativeCS2 = origin=(0mm, 0mm, 0.035mm) x=(1mm, 0mm, 0mm) y=(0mm, 1mm, 0mm) in RelativeCS1
  coordinate_system RelativeCS3 = origin=(0mm, 0mm, 0.813mm) x=(1mm, 0mm, 0mm) y=(0mm, 1mm, 0mm) in RelativeCS2
  coordinate_system RelativeCS4 = origin=(0mm, 0mm, 0.035mm) x=(1mm, 0mm, 0mm) y=(0mm, 1mm, 0mm) in RelativeCS3
  coordinate_system RelativeCS5 = origin=(0mm, 0mm, -0.848mm) x=(1mm, 0mm, 0mm) y=(0mm, 1mm, 0mm) in RelativeCS4
  Circle48 = circle(normal=Z, centre=(-26.464mm, -28mm, 0.848mm), radius=1mm) in RelativeCS5
  Circle48.move(0mm, 0mm, -0.848mm) in RelativeCS5
  Circle49 = circle(normal=Z, centre=(-26.464mm, -15mm, 0.883mm), radius=2mm)
  Circle51 = circle(normal=Z, centre=(-26.464mm, -15mm, 0.883mm), radius=1mm)
  Circle49.subtract(Circle51)
  Circle49.move(0mm, 0mm, 0.035mm)
  coordinate_system RelativeCS6 = origin=(0mm, 0mm, 0mm) x=(1mm, 0mm, 0mm) y=(0mm, 1mm, 0mm)
  coordinate_system RelativeCS7 = origin=(0mm, 0mm, 0.035mm) x=(1mm, 0mm, 0mm) y=(0mm, 1mm, 0mm) in RelativeCS6
  coordinate_system RelativeCS8 = origin=(0mm, 0mm, 0.813mm) x=(1mm, 0mm, 0mm) y=(0mm, 1mm, 0mm) in RelativeCS7
  coordinate_system RelativeCS9 = origin=(0mm, 0mm, 0.035mm) x=(1mm, 0mm, 0mm) y=(0mm, 1mm, 0mm) in RelativeCS8
  coordinate_system RelativeCS10 = origin=(0mm, 0mm, -0.848mm) x=(1mm, 0mm, 0mm) y=(0mm, 1mm, 0mm) in RelativeCS9
  Circle50 = circle(normal=Z, centre=(-26.464mm, -15mm, 0.848mm), radius=1mm) in RelativeCS10
  Circle50.move(0mm, 0mm, -0.848mm) in RelativeCS10
  Circle52 = circle(normal=Z, centre=(-26.464mm, 28mm, 0.883mm), radius=2mm)
  Circle56 = circle(normal=Z, centre=(-26.464mm, 28mm, 0.883mm), radius=1mm)
  Circle52.subtract(Circle56)
  Circle52.move(0mm, 0mm, 0.035mm)
  coordinate_system RelativeCS11 = origin=(0mm, 0mm, 0mm) x=(1mm, 0mm, 0mm) y=(0mm, 1mm, 0mm)
  coordinate_system RelativeCS12 = origin=(0mm, 0mm, 0.035mm) x=(1mm, 0mm, 0mm) y=(0mm, 1mm, 0mm) in RelativeCS11
  coordinate_system RelativeCS13 = origin=(0mm, 0mm, 0.813mm) x=(1mm, 0mm, 0mm) y=(0mm, 1mm, 0mm) in RelativeCS12
  coordinate_system RelativeCS14 = origin=(0mm, 0mm, 0.035mm) x=(1mm, 0mm, 0mm) y=(0mm, 1mm, 0mm) in RelativeCS13
  coordinate_system RelativeCS15 = origin=(0mm, 0mm, -0.848mm) x=(1mm, 0mm, 0mm) y=(0mm, 1mm, 0mm) in RelativeCS14
  Circle53 = circle(normal=Z, centre=(-26.464mm, 28mm, 0.848mm), radius=1mm) in RelativeCS15
  Circle53.move(0mm, 0mm, -0.848mm) in RelativeCS15
  Circle54 = circle(normal=Z, centre=(-26.464mm, 15mm, 0.883mm), radius=2mm)
  Circle57 = circle(normal=Z, centre=(-26.464mm, 15mm, 0.883mm), radius=1mm)
  Circle54.subtract(Circle57)
  Circle54.move(0mm, 0mm, 0.035mm)
  coordinate_system RelativeCS16 = origin=(0mm, 0mm, 0mm) x=(1mm, 0mm, 0mm) y=(0mm, 1mm, 0mm)
  coordinate_system RelativeCS17 = origin=(0mm, 0mm, 0.035mm) x=(1mm, 0mm, 0mm) y=(0mm, 1mm, 0mm) in RelativeCS16
  coordinate_system RelativeCS18 = origin=(0mm, 0mm, 0.813mm) x=(1mm, 0mm, 0mm) y=(0mm, 1mm, 0mm) in RelativeCS17
  coordinate_system RelativeCS19 = origin=(0mm, 0mm, 0.035mm) x=(1mm, 0mm, 0mm) y=(0mm, 1mm, 0mm) in RelativeCS18
  coordinate_system RelativeCS20 = origin=(0mm, 0mm, -0.848mm) x=(1mm, 0mm, 0mm) y=(0mm, 1mm, 0mm) in RelativeCS19
  Circle55 = circle(normal=Z, centre=(-26.464mm, 15mm, 0.848mm), radius=1mm) in RelativeCS20
  Circle55.move(0mm, 0mm, -0.848mm) in RelativeCS20
  Circle58 = circle(normal=Z, centre=(26.464mm, -28mm, 0.883mm), radius=2mm)
  Circle66 = circle(normal=Z, centre=(26.464mm, -28mm, 0.883mm), radius=1mm)
  Circle58.subtract(Circle66)
  Circle58.move(0mm, 0mm, 0.035mm)
  coordinate_system RelativeCS21 = origin=(0mm, 0mm, 0mm) x=(1mm, 0mm, 0mm) y=(0mm, 1mm, 0mm)
  coordinate_system RelativeCS22 = origin=(0mm, 0mm, 0.035mm) x=(1mm, 0mm, 0mm) y=(0mm, 1mm, 0mm) in RelativeCS21
  coordinate_system RelativeCS23 = origin=(0mm, 0mm, 0.813mm) x=(1mm, 0mm, 0mm) y=(0mm, 1mm, 0mm) in RelativeCS22
  coordinate_system RelativeCS24 = origin=(0mm, 0mm, 0.035mm) x=(1mm, 0mm, 0mm) y=(0mm, 1mm, 0mm) in RelativeCS23
  coordinate_system RelativeCS25 = origin=(0mm, 0mm, -0.848mm) x=(1mm, 0mm, 0mm) y=(0mm, 1mm, 0mm) in RelativeCS24
  Circle59 = circle(normal=Z, centre=(26.464mm, -28mm, 0.848mm), radius=1mm) in RelativeCS25
  Circle59.move(0mm, 0mm, -0.848mm) in RelativeCS25
  Circle60 = circle(normal=Z, centre=(26.464mm, -15mm, 0.883mm), radius=2mm)
  Circle67 = circle(normal=Z, centre=(26.464mm, -15mm, 0.883mm), radius=1mm)
  Circle60.subtract(Circle67)
  Circle60.move(0mm, 0mm, 0.035mm)
  coordinate_system RelativeCS26 = origin=(0mm, 0mm, 0mm) x=(1mm, 0mm, 0mm) y=(0mm, 1mm, 0mm)
  coordinate_system RelativeCS27 = origin=(0mm, 0mm, 0.035mm) x=(1mm, 0mm, 0mm) y=(0mm, 1mm, 0mm) in RelativeCS26
  coordinate_system RelativeCS28 = origin=(0mm, 0mm, 0.813mm) x=(1mm, 0mm, 0mm) y=(0mm, 1mm, 0mm) in RelativeCS27
  coordinate_system RelativeCS29 = origin=(0mm, 0mm, 0.035mm) x=(1mm, 0mm, 0mm) y=(0mm, 1mm, 0mm) in RelativeCS28
  coordinate_system RelativeCS30 = origin=(0mm, 0mm, -0.848mm) x=(1mm, 0mm, 0mm) y=(0mm, 1mm, 0mm) in RelativeCS29
  Circle61 = circle(normal=Z, centre=(26.464mm, -15mm, 0.848mm), radius=1mm) in RelativeCS30
  Circle61.move(0mm, 0mm, -0.848mm) in RelativeCS30
  Circle62 = circle(normal=Z, centre=(26.464mm, 28mm, 0.883mm), radius=2mm)
  Circle68 = circle(normal=Z, centre=(26.464mm, 28mm, 0.883mm), radius=1mm)
  Circle62.subtract(Circle68)
  Circle62.move(0mm, 0mm, 0.035mm)
  coordinate_system RelativeCS31 = origin=(0mm, 0mm, 0mm) x=(1mm, 0mm, 0mm) y=(0mm, 1mm, 0mm)
  coordinate_system RelativeCS32 = origin=(0mm, 0mm, 0.035mm) x=(1mm, 0mm, 0mm) y=(0mm, 1mm, 0mm) in RelativeCS31
  coordinate_system RelativeCS33 = origin=(0mm, 0mm, 0.813mm) x=(1mm, 0mm, 0mm) y=(0mm, 1mm, 0mm) in RelativeCS32
  coordinate_system RelativeCS34 = origin=(0mm, 0mm, 0.035mm) x=(1mm, 0mm, 0mm) y=(0mm, 1mm, 0mm) in RelativeCS33
  coordinate_system RelativeCS35 = origin=(0mm, 0mm, -0.848mm) x=(1mm, 0mm, 0mm) y=(0mm, 1mm, 0mm) in RelativeCS34
  Circle63 = circle(normal=Z, centre=(26.464mm, 28mm, 0.848mm), radius=1mm) in RelativeCS35
  Circle63.move(0mm, 0mm, -0.848mm) in RelativeCS35
  Circle64 = circle(normal=Z, centre=(26.464mm, 15mm, 0.883mm), radius=2mm)
  Circle69 = circle(normal=Z, centre=(26.464mm, 15mm, 0.883mm), radius=1mm)
  Circle64.subtract(Circle69)
  Circle64.move(0mm, 0mm, 0.035mm)
  coordinate_system RelativeCS36 = origin=(0mm, 0mm, 0mm) x=(1mm, 0mm, 0mm) y=(0mm, 1mm, 0mm)
  coordinate_system RelativeCS37 = origin=(0mm, 0mm, 0.035mm) x=(1mm, 0mm, 0mm) y=(0mm, 1mm, 0mm) in RelativeCS36
  coordinate_system RelativeCS38 = origin=(0mm, 0mm, 0.813mm) x=(1mm, 0mm, 0mm) y=(0mm, 1mm, 0mm) in RelativeCS37
  coordinate_system RelativeCS39 = origin=(0mm, 0mm, 0.035mm) x=(1mm, 0mm, 0mm) y=(0mm, 1mm, 0mm) in RelativeCS38
  coordinate_system RelativeCS40 = origin=(0mm, 0mm, -0.848mm) x=(1mm, 0mm, 0mm) y=(0mm, 1mm, 0mm) in RelativeCS39
  Circle65 = circle(normal=Z, centre=(26.464mm, 15mm, 0.848mm), radius=1mm) in RelativeCS40
  Circle65.move(0mm, 0mm, -0.848mm) in RelativeCS40
  Substrate_3.unite(Substrate_4, Substrate_17, Polyline13, Polyline24, Polyline28, Polyline29)
  Substrate_5.unite(Substrate_18, Substrate_20, Polyline18, Polyline26, Polyline27, Polyline30)
  Cylinder16 = cylinder(axis=Z, base_centre=(0mm, (21.9+1.3) mm, 0.035mm), radius=0.35mm, height=-0.035mm)
  Cylinder16.rotate(axis=Z, angle=55deg)
  Cylinder16.move(-0.61747602mm, 0.41776754mm, 1.110223e-16mm)
  Cylinder17 = cylinder(axis=Z, base_centre=(0.8mm, (21.9+1.3) mm, 0.035mm), radius=0.35mm, height=-0.035mm)
  Cylinder17.rotate(axis=Z, angle=55deg)
  Cylinder17.move(-0.61747602mm, 0.41776754mm, 1.110223e-16mm)
  Cylinder18 = cylinder(axis=Z, base_centre=(-0.8mm, (21.9+1.3) mm, 0.035mm), radius=0.35mm, height=-0.035mm)
  Cylinder18.rotate(axis=Z, angle=55deg)
  Cylinder18.move(-0.61747602mm, 0.41776754mm, 1.110223e-16mm)
  Substrate_14.subtract(Cylinder1, Cylinder2, Cylinder3)
  Substrate_7.subtract(Cylinder16, Cylinder17, Cylinder18)
  Substrate_33 = box(corner=(-10mm, 35mm, 0.883mm), size=(20mm, -3mm, -0.035mm))
  Substrate_34 = box(corner=(-10mm, 35mm, 0mm), size=(20mm, -3mm, 0.035mm))
  Substrate_7.subtract(Substrate_34)
  coordinate_system RelativeCS41 = origin=(0mm, 0mm, 0.883mm) x=(1mm, 0mm, 0mm) y=(0mm, 1mm, 0mm)
  coordinate_system RelativeCS42 = origin=(0mm, 0mm, -0.883mm) x=(1mm, 0mm, 0mm) y=(0mm, 1mm, 0mm) in RelativeCS41
boundaries and excitations:
  Rad1: Radiation Objects=air_box
  1: Wave Port Objects=Rectangle1 WavePortType=Modal NumModes=1 Modes{Mode1{IntLine{(0, -35, 0.883) -> (0, -35, 0)} CharImp=Zpi}}
  2: Wave Port Objects=Rectangle2 WavePortType=Modal NumModes=1 Modes{Mode1{IntLine{(0, 35, -0.883) -> (0, 35, 0)} CharImp=Zpi}}
setups:
  Setup16: HfssDriven Frequency=3GHz MaxDeltaS=0.005 MaximumPasses=20 MinimumPasses=6 MinimumConvergedPasses=2 PercentRefinement=30 BasisOrder=1 PortAccuracy=2 DrivenSolverType="Direct Solver"
    sweep Sweep: 0.01GHz to 5GHz step 0.01GHz; Type=Discrete
  Setup18: HfssDriven Frequency=4GHz MaxDeltaS=0.005 MaximumPasses=20 MinimumPasses=6 MinimumConvergedPasses=2 PercentRefinement=30 BasisOrder=1 PortAccuracy=2 DrivenSolverType="Direct Solver"
    sweep Sweep: 0.01GHz to 5GHz step 0.01GHz; Type=Discrete
source amplitudes:
  1:1: 1W 0deg
  2:1: 0W 0deg
output variables:
  sdd21 = arg((S(2,1)-S(3,1)-S(2,4)+S(3,4))/2)
  sdd11 = mag((S(1,1)-S(4,1)-S(1,4)+S(4,4))/2)
  scc21 = arg((S(2,1)+S(3,1)+S(2,4)+S(3,4))/2)
  scc11 = mag((S(1,1)+S(4,1)+S(1,4)+S(4,4))/2)
  scd21 = mag((S(2,1)-S(2,4)+S(3,1)-S(3,4))/2)
  scd11 = mag((S(1,1)-S(1,4)+S(4,1)-S(4,4))/2)
  sdc11 = mag((S(1,1)+S(1,4)-S(4,1)-S(4,4))/2)
  sdc21 = mag((S(2,1)+S(2,4)-S(3,1)-S(3,2))/2)
reports:
  XY Plot 18: dB(S(1,1)), dB(S(1,2)), dB(S(2,1)), dB(S(2,2)) vs Freq on Setup16 : Sweep; markers m1 at 1.08GHz, m2 at 3.54GHz, m3 at 2.58GHz, m4 at 3.76GHz
  XY Plot 20: dB(S(1,1)), dB(S(1,2)), dB(S(2,1)), dB(S(2,2)) vs Freq on Setup18 : Sweep; markers m1 at 2.6GHz, m2 at 1.13GHz, m3 at 0.01GHz, m4 at 0.01GHz

design 3-section shunt-type filter (HFSS, HFSS Modal Network, model units mm)
options: Save_Adaptive_support_files
geometry:
  Substrate_1 [Rogers RO4003 (tm)] = box(corner=(-35.5mm, -52mm, 0.035mm), size=((35.5*2) mm, (52*2) mm, 0.813mm))
  air_box [air] = box(corner=(-35.5mm, -52mm, -23mm), size=((35.5*2) mm, (52*2) mm, (23*2) mm))
  Substrate_2 [Rogers RO4003 (tm)] = box(corner=(-35.5mm, -52mm, -0.035mm), size=((35.5*2) mm, (52*2) mm, -0.813mm))
  Substrate_4 [copper] = box(corner=(-0.91mm, 0mm, 0.848mm), size=(1.82mm, -52mm, 0.035mm))
  Substrate_5 [copper] = box(corner=(-0.91mm, 0mm, -0.848mm), size=(1.82mm, 52mm, -0.035mm))
  Substrate_7 [copper] = box(corner=(-35.5mm, -52mm, 0mm), size=((35.5*2) mm, (52*2) mm, 0.035mm))
  Substrate_9 [copper] = box(corner=(-35.5mm, -52mm, 0mm), size=((35.5*2) mm, (52*2) mm, -0.035mm))
  Rectangle1 = rectangle(corner=(-7.52mm, -52mm, 0mm), z_size=6.504mm, x_size=15.04mm)
  Substrate_10 = box(corner=((-50.4/2) mm, (-0.44/2) mm, 0mm), size=(50.4mm, 0.44mm, 0.035mm))
  Substrate_12 = box(corner=((-50.4/2) mm, (-0.44/2) mm, 0mm), size=(50.4mm, 0.44mm, -0.035mm))
  Substrate_7.subtract(Substrate_10)
  Substrate_9.subtract(Substrate_12)
  Cylinder1 = cylinder(axis=Z, base_centre=(0mm, (100+0.635+0.65) mm, 0.848mm), radius=0.35mm, height=-0.813mm)
  Rectangle2 = rectangle(corner=(-7.52mm, 52mm, 0mm), z_size=-6.504mm, x_size=15.04mm)
  Polyline13 = polyline(z=0.883mm, xy in mm: (2.8868095, 1.610085) (5.6434672, 0.64346717) (5.6434672, 21.843467) (3.1234672, 21.843467) (2.8868095, 1.610085), closed, covered)
  Polyline13.sweep_along_vector((0mm, 0mm, -0.035mm))
  Box1 = box(corner=(3.1234672mm, 21.843467mm, 0.883mm), size=(2.52mm, -20.233382mm, -0.035mm))
  Polyline13.subtract(Box1)
  Box2 [copper] = box(corner=(3.1234672mm, 21.843467mm, 0.883mm), size=(2.52mm, -20.233382mm, -0.035mm))
  Box2.unite(Polyline13)
  Box2.rotate(axis=Z, angle=-45deg)
  Box2.move(-3.5355339mm, 3.5355339mm, -1.110223e-16mm)
  Box3 [copper] = box(corner=(-0.69mm, 100mm, 0.883mm), size=(1.38mm, -21.45mm, -0.035mm))
  Circle1 = circle(normal=Z, centre=(-10mm, 100mm, 0.883mm), radius=2.2mm)
  Circle2 = circle(normal=Z, centre=(-10mm, 100mm, 0.883mm), radius=4.95mm)
  Circle2.subtract(Circle1)
  Rectangle3 [copper] = rectangle(corner=(-10mm, (100-5) mm, 0.883mm), x_size=5mm, y_size=10mm)
  Rectangle3.intersect(Circle2)
  Rectangle3.sweep_along_vector((0mm, 0mm, -0.035mm))
  Rectangle4 = rectangle(corner=(-10mm, (100-5) mm, 0.883mm), x_size=5mm, y_size=10mm)
  Circle4 = circle(normal=Z, centre=(-10mm, 100mm, 0.883mm), radius=4.95mm)
  Circle3 = circle(normal=Z, centre=(-10mm, 100mm, 0.883mm), radius=2.2mm)
  Circle4.subtract(Circle3)
  Rectangle4.intersect(Circle4)
  Rectangle4.sweep_along_vector((0mm, 0mm, -0.035mm))
  Rectangle4.rotate(axis=Z, angle=-180deg)
  Rectangle4.move(-20mm, 192.85mm, 0mm)
  Rectangle3.unite(Rectangle4)
  Rectangle3.rotate(axis=Z, angle=-90deg)
  Rectangle3.move(-103.575mm, 68.55mm, 0mm)
  Polyline14 [copper] = polyline(z=0.883mm, xy in mm: (-14.65, 56.45) (-13.635022, 56.681449) (-13.95, 78.55) (-14.65, 78.55) (-14.65, 56.45), closed, covered)
  Polyline14.sweep_along_vector((0mm, 0mm, -0.035mm))
  Rectangle5 = rectangle(corner=(0.69mm, 100mm, 0.883mm), x_size=-1.38mm, y_size=0.635mm)
  Box4 [copper] = box(corner=((2.7/2) mm, 100.635mm, 0.883mm), size=(-2.7mm, 1.2mm, -0.035mm))
  Cylinder16 = cylinder(axis=Z, base_centre=((0-0.85) mm, (100+0.635+0.65) mm, 0.848mm), radius=0.35mm, height=-0.813mm)
  Cylinder17 = cylinder(axis=Z, base_centre=((0+0.85) mm, (100+0.635+0.65) mm, 0.848mm), radius=0.35mm, height=-0.813mm)
  [Cylinder1, Box3, Rectangle3, Polyline14, Rectangle5, Box4, Cylinder16, Cylinder17].rotate(axis=Z, angle=45deg)
  [Cylinder1, Box3, Rectangle3, Polyline14, Rectangle5, Box4, Cylinder16, Cylinder17].move(49.365292mm, -29.557063mm, -1.110223e-16mm)
  Polyline15 [copper] = polyline(z=0.883mm, xy in mm: (-0.91, 0) (-0.35596146, 0.88135735) (0.91, 0) (-0.91, 0), closed, covered)
  Polyline15.sweep_along_vector((0mm, 0mm, -0.035mm))
  Polyline16 [copper] = polyline(z=0.883mm, xy in mm: (0.91, 0) (-0.35596146, 0.88135735) (-0.35574933, 2.6327534) (0.91, 0), closed, covered)
  Polyline16.sweep_along_vector((0mm, 0mm, -0.035mm))
  Box2_1 [copper] = Box2.duplicate_around_axis(axis=Z, angle=180deg, total=2)
  Box2_1.move(1.110223e-16mm, 0mm, -1.731mm)
  Polyline16_1 [copper] = Polyline16.duplicate_around_axis(axis=Z, angle=180deg, total=2)
  Polyline15_1 [copper] = Polyline15.duplicate_around_axis(axis=Z, angle=180deg, total=2)
  Polyline15_1.move(3.4416914e-15mm, 0mm, -1.731mm)
  Polyline16_1.move(3.4416914e-15mm, 1.110223e-16mm, -1.731mm)
  Polyline14_1 [copper] = Polyline14.duplicate_around_axis(axis=Z, angle=180deg, total=2)
  Rectangle3_1 [copper] = Rectangle3.duplicate_around_axis(axis=Z, angle=180deg, total=2)
  Box3_1 [copper] = Box3.duplicate_around_axis(axis=Z, angle=180deg, total=2)
  Rectangle5_1 = Rectangle5.duplicate_around_axis(axis=Z, angle=180deg, total=2)
  Cylinder16_1 = Cylinder16.duplicate_around_axis(axis=Z, angle=180deg, total=2)
  Cylinder1_1 = Cylinder1.duplicate_around_axis(axis=Z, angle=180deg, total=2)
  Cylinder17_1 = Cylinder17.duplicate_around_axis(axis=Z, angle=180deg, total=2)
  Box4_1 [copper] = Box4.duplicate_around_axis(axis=Z, angle=180deg, total=2)
  [Polyline14_1, Rectangle3_1, Box3_1, Rectangle5_1, Box4_1].move(3.4416914e-15mm, 0mm, -1.731mm)
  Rectangle5_1.move(0mm, 0mm, -0.035mm)
  [Cylinder17_1, Cylinder1_1, Cylinder16_1].move(0mm, 0mm, -0.883mm)
  Substrate_1.subtract(Cylinder1, Cylinder16, Cylinder17)
  Cylinder18 [copper] = cylinder(axis=Z, base_centre=(0mm, (100+0.635+0.65) mm, 0.848mm), radius=0.35mm, height=-0.813mm)
  Cylinder18.rotate(axis=Z, angle=45deg)
  Cylinder18.move(49.365292mm, -29.557063mm, -1.110223e-16mm)
  Cylinder19 [copper] = cylinder(axis=Z, base_centre=((0-0.85) mm, (100+0.635+0.65) mm, 0.848mm), radius=0.35mm, height=-0.813mm)
  Cylinder19.rotate(axis=Z, angle=45deg)
  Cylinder19.move(49.365292mm, -29.557063mm, -1.110223e-16mm)
  Cylinder20 [copper] = cylinder(axis=Z, base_centre=((0+0.85) mm, (100+0.635+0.65) mm, 0.848mm), radius=0.35mm, height=-0.813mm)
  Cylinder20.rotate(axis=Z, angle=45deg)
  Cylinder20.move(49.365292mm, -29.557063mm, -1.110223e-16mm)
  Substrate_2.subtract(Cylinder1_1, Cylinder16_1, Cylinder17_1)
  Cylinder22 = cylinder(axis=Z, base_centre=((0-0.85) mm, (100+0.635+0.65) mm, 0.848mm), radius=0.35mm, height=-0.813mm)
  Cylinder22.rotate(axis=Z, angle=45deg)
  Cylinder22.move(49.365292mm, -29.557063mm, -1.110223e-16mm)
  Cylinder16_2 [copper] = Cylinder22.duplicate_around_axis(axis=Z, angle=180deg, total=2)
  Cylinder22.delete()
  Cylinder16_2.move(0mm, 0mm, -0.883mm)
  Cylinder21 = cylinder(axis=Z, base_centre=(0mm, (100+0.635+0.65) mm, 0.848mm), radius=0.35mm, height=-0.813mm)
  Cylinder21.rotate(axis=Z, angle=45deg)
  Cylinder21.move(49.365292mm, -29.557063mm, -1.110223e-16mm)
  Cylinder1_2 [copper] = Cylinder21.duplicate_around_axis(axis=Z, angle=180deg, total=2)
  Cylinder21.delete()
  Cylinder1_2.move(0mm, 0mm, -0.883mm)
  Cylinder23 = cylinder(axis=Z, base_centre=((0+0.85) mm, (100+0.635+0.65) mm, 0.848mm), radius=0.35mm, height=-0.813mm)
  Cylinder23.rotate(axis=Z, angle=45deg)
  Cylinder23.move(49.365292mm, -29.557063mm, -1.110223e-16mm)
  Cylinder17_2 [copper] = Cylinder23.duplicate_around_axis(axis=Z, angle=180deg, total=2)
  Cylinder23.delete()
  Cylinder17_2.move(0mm, 0mm, -0.883mm)
boundaries and excitations:
  Rad1: Radiation Objects=air_box
  LumpRLC1: Lumped RLC Objects=Rectangle5 CurrentLine{(-21.345386, 41.153615, 0.883) -> (-21.794399, 41.602627, 0.883)} RLC_Type=Parallel Resistance=50ohm
  LumpRLC2: Lumped RLC Objects=Rectangle5_1 CurrentLine{(21.345386, -41.153615, -0.883) -> (21.794399, -41.602627, -0.883)} RLC_Type=Parallel Resistance=50ohm
  1: Wave Port Objects=Rectangle1 WavePortType=Modal NumModes=1 Modes{Mode1{IntLine{(0, -52, 0.883) -> (0, -52, 0)} CharImp=Zpi}}
  2: Wave Port Objects=Rectangle2 WavePortType=Modal NumModes=1 Modes{Mode1{IntLine{(0, 52, -0.883) -> (0, 52, 0)} CharImp=Zpi}}
setups:
  Setup18: HfssDriven Frequency=4GHz MaxDeltaS=0.005 MaximumPasses=20 MinimumPasses=6 MinimumConvergedPasses=2 PercentRefinement=30 BasisOrder=1 PortAccuracy=2 DrivenSolverType="Direct Solver"
    sweep Sweep: 0.01GHz to 5GHz step 0.01GHz; Type=Discrete
  Setup19: HfssDriven Frequency=4.2GHz MaxDeltaS=0.005 MaximumPasses=30 MinimumPasses=6 MinimumConvergedPasses=2 PercentRefinement=30 BasisOrder=1 PortAccuracy=2 DrivenSolverType="Direct Solver"
    sweep Sweep: 0.01GHz to 5GHz step 0.01GHz; Type=Fast
  Setup20: HfssDriven Frequency=4.5GHz MaxDeltaS=0.005 MaximumPasses=30 MinimumPasses=6 MinimumConvergedPasses=2 PercentRefinement=30 BasisOrder=1 PortAccuracy=2 DrivenSolverType="Direct Solver"
    sweep Sweep: 0.01GHz to 5GHz step 0.01GHz; Type=Fast
  Setup21: HfssDriven Frequency=4.5GHz MaxDeltaS=0.005 MaximumPasses=30 MinimumPasses=6 MinimumConvergedPasses=2 PercentRefinement=30 BasisOrder=1 PortAccuracy=2 DrivenSolverType="Direct Solver"
    sweep Sweep: 0.01GHz to 5GHz step 0.01GHz; Type=Discrete
  Setup22: HfssDriven Frequency=5GHz MaxDeltaS=0.005 MaximumPasses=30 MinimumPasses=6 MinimumConvergedPasses=2 PercentRefinement=30 BasisOrder=1 PortAccuracy=2 DrivenSolverType="Direct Solver"
    sweep Sweep: 0.01GHz to 5GHz step 0.01GHz; Type=Discrete
source amplitudes:
  1:1: 1W 0deg
  2:1: 0W 0deg
output variables:
  sdd21 = arg((S(2,1)-S(3,1)-S(2,4)+S(3,4))/2)
  sdd11 = mag((S(1,1)-S(4,1)-S(1,4)+S(4,4))/2)
  scc21 = arg((S(2,1)+S(3,1)+S(2,4)+S(3,4))/2)
  scc11 = mag((S(1,1)+S(4,1)+S(1,4)+S(4,4))/2)
  scd21 = mag((S(2,1)-S(2,4)+S(3,1)-S(3,4))/2)
  scd11 = mag((S(1,1)-S(1,4)+S(4,1)-S(4,4))/2)
  sdc11 = mag((S(1,1)+S(1,4)-S(4,1)-S(4,4))/2)
  sdc21 = mag((S(2,1)+S(2,4)-S(3,1)-S(3,2))/2)
reports:
  XY Plot 20: dB(S(1,1)), dB(S(1,2)), dB(S(2,1)), dB(S(2,2)) vs Freq on Setup18 : Sweep; markers m1 at 2.6GHz, m2 at 1.13GHz, m3 at 0.01GHz, m4 at 0.01GHz
  S Parameter Plot 1: dB(S(1,1)), dB(S(2,1)) vs Freq on Setup19 : Sweep; markers m1 at 2.59GHz, m2 at 2.05GHz, m3 at 1.21GHz, m4 at 2.83GHz
  S Parameter Plot 2: dB(S(1,1)), dB(S(1,2)), dB(S(2,1)), dB(S(2,2)) vs Freq on Setup20 : Sweep; markers m1 at 3.28GHz, m2 at 0.6GHz, m3 at 2.09GHz, m4 at 1.21GHz, m5 at 2.83GHz, m6 at 0.37GHz
  S Parameter Plot 4: dB(S(1,1)), dB(S(1,2)), dB(S(2,1)), dB(S(2,2)) vs Freq on Setup22 : Sweep

design 3-section shunt-type filter-fabrication (HFSS, HFSS Modal Network, model units mm)
options: Save_Adaptive_support_files
geometry:
  Substrate_1 [Rogers RO4003 (tm)] = box(corner=(-40mm, -52mm, 0.035mm), size=((40*2) mm, (52*2) mm, 0.813mm))
  air_box [air] = box(corner=(-40mm, -52mm, -23mm), size=((40*2) mm, (52*2) mm, (23*2) mm))
  Substrate_2 [Rogers RO4003 (tm)] = box(corner=(-40mm, -52mm, -0.035mm), size=((40*2) mm, (52*2) mm, -0.813mm))
  Substrate_4 [copper] = box(corner=(-0.91mm, 0mm, 0.848mm), size=(1.82mm, -52mm, 0.035mm))
  Substrate_5 [copper] = box(corner=(-0.91mm, 0mm, -0.848mm), size=(1.82mm, 52mm, -0.035mm))
  Substrate_7 [copper] = box(corner=(-40mm, -52mm, 0mm), size=((40*2) mm, (52*2) mm, 0.035mm))
  Substrate_9 [copper] = box(corner=(-40mm, -52mm, 0mm), size=((40*2) mm, (52*2) mm, -0.035mm))
  Substrate_10 = box(corner=((-50.4/2) mm, (-0.44/2) mm, 0mm), size=(50.4mm, 0.44mm, 0.035mm))
  Substrate_12 = box(corner=((-50.4/2) mm, (-0.44/2) mm, 0mm), size=(50.4mm, 0.44mm, -0.035mm))
  Substrate_7.subtract(Substrate_10)
  Substrate_9.subtract(Substrate_12)
  Cylinder1 = cylinder(axis=Z, base_centre=(0mm, (100+0.635+0.65) mm, 0.848mm), radius=0.35mm, height=-0.813mm)
  Polyline13 = polyline(z=0.883mm, xy in mm: (2.8868095, 1.610085) (5.6434672, 0.64346717) (5.6434672, 21.843467) (3.1234672, 21.843467) (2.8868095, 1.610085), closed, covered)
  Polyline13.sweep_along_vector((0mm, 0mm, -0.035mm))
  Box1 = box(corner=(3.1234672mm, 21.843467mm, 0.883mm), size=(2.52mm, -20.233382mm, -0.035mm))
  Polyline13.subtract(Box1)
  Box2 = box(corner=(3.1234672mm, 21.843467mm, 0.883mm), size=(2.52mm, -20.233382mm, -0.035mm))
  Box2.unite(Polyline13)
  Box2.rotate(axis=Z, angle=-45deg)
  Box2.move(-3.5355339mm, 3.5355339mm, -1.110223e-16mm)
  Box3 = box(corner=(-0.69mm, 100mm, 0.883mm), size=(1.38mm, -21.45mm, -0.035mm))
  Circle1 = circle(normal=Z, centre=(-10mm, 100mm, 0.883mm), radius=2.2mm)
  Circle2 = circle(normal=Z, centre=(-10mm, 100mm, 0.883mm), radius=4.95mm)
  Circle2.subtract(Circle1)
  Rectangle3 = rectangle(corner=(-10mm, (100-5) mm, 0.883mm), x_size=5mm, y_size=10mm)
  Rectangle3.intersect(Circle2)
  Rectangle3.sweep_along_vector((0mm, 0mm, -0.035mm))
  Rectangle4 = rectangle(corner=(-10mm, (100-5) mm, 0.883mm), x_size=5mm, y_size=10mm)
  Circle4 = circle(normal=Z, centre=(-10mm, 100mm, 0.883mm), radius=4.95mm)
  Circle3 = circle(normal=Z, centre=(-10mm, 100mm, 0.883mm), radius=2.2mm)
  Circle4.subtract(Circle3)
  Rectangle4.intersect(Circle4)
  Rectangle4.sweep_along_vector((0mm, 0mm, -0.035mm))
  Rectangle4.rotate(axis=Z, angle=-180deg)
  Rectangle4.move(-20mm, 192.85mm, 0mm)
  Rectangle3.unite(Rectangle4)
  Rectangle3.rotate(axis=Z, angle=-90deg)
  Rectangle3.move(-103.575mm, 68.55mm, 0mm)
  Polyline14 = polyline(z=0.883mm, xy in mm: (-14.65, 56.45) (-13.635022, 56.681449) (-13.95, 78.55) (-14.65, 78.55) (-14.65, 56.45), closed, covered)
  Polyline14.sweep_along_vector((0mm, 0mm, -0.035mm))
  Rectangle5 = rectangle(corner=(0.69mm, 100mm, 0.883mm), x_size=-1.38mm, y_size=0.635mm)
  Box4 [copper] = box(corner=((2.7/2) mm, 100.635mm, 0.883mm), size=(-2.7mm, 1.2mm, -0.035mm))
  Cylinder16 = cylinder(axis=Z, base_centre=((0-0.85) mm, (100+0.635+0.65) mm, 0.848mm), radius=0.35mm, height=-0.813mm)
  Cylinder17 = cylinder(axis=Z, base_centre=((0+0.85) mm, (100+0.635+0.65) mm, 0.848mm), radius=0.35mm, height=-0.813mm)
  [Cylinder1, Box3, Rectangle3, Polyline14, Rectangle5, Box4, Cylinder16, Cylinder17].rotate(axis=Z, angle=45deg)
  [Cylinder1, Box3, Rectangle3, Polyline14, Rectangle5, Box4, Cylinder16, Cylinder17].move(49.365292mm, -29.557063mm, -1.110223e-16mm)
  Polyline15 = polyline(z=0.883mm, xy in mm: (-0.91, 0) (-0.35596146, 0.88135735) (0.91, 0) (-0.91, 0), closed, covered)
  Polyline15.sweep_along_vector((0mm, 0mm, -0.035mm))
  Polyline16 = polyline(z=0.883mm, xy in mm: (0.91, 0) (-0.35596146, 0.88135735) (-0.35574933, 2.6327534) (0.91, 0), closed, covered)
  Polyline16.sweep_along_vector((0mm, 0mm, -0.035mm))
  Box2_1 = Box2.duplicate_around_axis(axis=Z, angle=180deg, total=2)
  Box2_1.move(1.110223e-16mm, 0mm, -1.731mm)
  Polyline16_1 = Polyline16.duplicate_around_axis(axis=Z, angle=180deg, total=2)
  Polyline15_1 = Polyline15.duplicate_around_axis(axis=Z, angle=180deg, total=2)
  Polyline15_1.move(3.4416914e-15mm, 0mm, -1.731mm)
  Polyline16_1.move(3.4416914e-15mm, 1.110223e-16mm, -1.731mm)
  Polyline14_1 = Polyline14.duplicate_around_axis(axis=Z, angle=180deg, total=2)
  Rectangle3_1 = Rectangle3.duplicate_around_axis(axis=Z, angle=180deg, total=2)
  Box3_1 = Box3.duplicate_around_axis(axis=Z, angle=180deg, total=2)
  Rectangle5_1 = Rectangle5.duplicate_around_axis(axis=Z, angle=180deg, total=2)
  Cylinder16_1 = Cylinder16.duplicate_around_axis(axis=Z, angle=180deg, total=2)
  Cylinder1_1 = Cylinder1.duplicate_around_axis(axis=Z, angle=180deg, total=2)
  Cylinder17_1 = Cylinder17.duplicate_around_axis(axis=Z, angle=180deg, total=2)
  Box4_1 [copper] = Box4.duplicate_around_axis(axis=Z, angle=180deg, total=2)
  [Polyline14_1, Rectangle3_1, Box3_1, Rectangle5_1, Box4_1].move(3.4416914e-15mm, 0mm, -1.731mm)
  Rectangle5_1.move(0mm, 0mm, -0.035mm)
  [Cylinder17_1, Cylinder1_1, Cylinder16_1].move(0mm, 0mm, -0.883mm)
  Substrate_1.subtract(Cylinder1, Cylinder16, Cylinder17)
  Cylinder18 [copper] = cylinder(axis=Z, base_centre=(0mm, (100+0.635+0.65) mm, 0.848mm), radius=0.35mm, height=-0.813mm)
  Cylinder18.rotate(axis=Z, angle=45deg)
  Cylinder18.move(49.365292mm, -29.557063mm, -1.110223e-16mm)
  Cylinder19 [copper] = cylinder(axis=Z, base_centre=((0-0.85) mm, (100+0.635+0.65) mm, 0.848mm), radius=0.35mm, height=-0.813mm)
  Cylinder19.rotate(axis=Z, angle=45deg)
  Cylinder19.move(49.365292mm, -29.557063mm, -1.110223e-16mm)
  Cylinder20 [copper] = cylinder(axis=Z, base_centre=((0+0.85) mm, (100+0.635+0.65) mm, 0.848mm), radius=0.35mm, height=-0.813mm)
  Cylinder20.rotate(axis=Z, angle=45deg)
  Cylinder20.move(49.365292mm, -29.557063mm, -1.110223e-16mm)
  Substrate_2.subtract(Cylinder1_1, Cylinder16_1, Cylinder17_1)
  Cylinder22 = cylinder(axis=Z, base_centre=((0-0.85) mm, (100+0.635+0.65) mm, 0.848mm), radius=0.35mm, height=-0.813mm)
  Cylinder22.rotate(axis=Z, angle=45deg)
  Cylinder22.move(49.365292mm, -29.557063mm, -1.110223e-16mm)
  Cylinder16_2 [copper] = Cylinder22.duplicate_around_axis(axis=Z, angle=180deg, total=2)
  Cylinder22.delete()
  Cylinder16_2.move(0mm, 0mm, -0.883mm)
  Cylinder21 = cylinder(axis=Z, base_centre=(0mm, (100+0.635+0.65) mm, 0.848mm), radius=0.35mm, height=-0.813mm)
  Cylinder21.rotate(axis=Z, angle=45deg)
  Cylinder21.move(49.365292mm, -29.557063mm, -1.110223e-16mm)
  Cylinder1_2 [copper] = Cylinder21.duplicate_around_axis(axis=Z, angle=180deg, total=2)
  Cylinder21.delete()
  Cylinder1_2.move(0mm, 0mm, -0.883mm)
  Cylinder23 = cylinder(axis=Z, base_centre=((0+0.85) mm, (100+0.635+0.65) mm, 0.848mm), radius=0.35mm, height=-0.813mm)
  Cylinder23.rotate(axis=Z, angle=45deg)
  Cylinder23.move(49.365292mm, -29.557063mm, -1.110223e-16mm)
  Cylinder17_2 [copper] = Cylinder23.duplicate_around_axis(axis=Z, angle=180deg, total=2)
  Cylinder23.delete()
  Cylinder17_2.move(0mm, 0mm, -0.883mm)
  Substrate_4.unite(Box2, Polyline16, Polyline15, Polyline14, Rectangle3, Box3)
  Substrate_5.unite(Box2_1, Polyline15_1, Polyline16_1, Polyline14_1, Rectangle3_1, Box3_1)
  Substrate_33 = box(corner=(-10mm, 52mm, (0.883-0.035) mm), size=(20mm, -3mm, -0.813mm))
  Substrate_34 = box(corner=(-10mm, -52mm, (-0.883+0.035) mm), size=(20mm, 3mm, 0.813mm))
  Substrate_1.subtract(Substrate_33)
  Substrate_2.subtract(Substrate_34)
  Circle17 = circle(normal=Z, centre=(-30mm, -40mm, 0.883mm), radius=2mm)
  Circle19 = circle(normal=Z, centre=(-30mm, -40mm, 0.883mm), radius=1mm)
  Circle17.subtract(Circle19)
  Circle17.move(0mm, 0mm, 0.035mm)
  coordinate_system RelativeCS1 = origin=(0mm, 0mm, 0mm) x=(1mm, 0mm, 0mm) y=(0mm, 1mm, 0mm)
  coordinate_system RelativeCS2 = origin=(0mm, 0mm, 0.035mm) x=(1mm, 0mm, 0mm) y=(0mm, 1mm, 0mm) in RelativeCS1
  coordinate_system RelativeCS3 = origin=(0mm, 0mm, 0.813mm) x=(1mm, 0mm, 0mm) y=(0mm, 1mm, 0mm) in RelativeCS2
  coordinate_system RelativeCS4 = origin=(0mm, 0mm, 0.035mm) x=(1mm, 0mm, 0mm) y=(0mm, 1mm, 0mm) in RelativeCS3
  coordinate_system RelativeCS5 = origin=(0mm, 0mm, -0.848mm) x=(1mm, 0mm, 0mm) y=(0mm, 1mm, 0mm) in RelativeCS4
  Circle48 = circle(normal=Z, centre=(-30mm, -40mm, 0.035mm), radius=1mm) in RelativeCS5
  Circle48.move(0mm, 0mm, -0.848mm) in RelativeCS5
  Circle49 = circle(normal=Z, centre=(-30mm, 40mm, 0.883mm), radius=2mm)
  Circle51 = circle(normal=Z, centre=(-30mm, 40mm, 0.883mm), radius=1mm)
  Circle49.subtract(Circle51)
  Circle49.move(0mm, 0mm, 0.035mm)
  coordinate_system RelativeCS6 = origin=(0mm, 0mm, 0mm) x=(1mm, 0mm, 0mm) y=(0mm, 1mm, 0mm)
  coordinate_system RelativeCS7 = origin=(0mm, 0mm, 0.035mm) x=(1mm, 0mm, 0mm) y=(0mm, 1mm, 0mm) in RelativeCS6
  coordinate_system RelativeCS8 = origin=(0mm, 0mm, 0.813mm) x=(1mm, 0mm, 0mm) y=(0mm, 1mm, 0mm) in RelativeCS7
  coordinate_system RelativeCS9 = origin=(0mm, 0mm, 0.035mm) x=(1mm, 0mm, 0mm) y=(0mm, 1mm, 0mm) in RelativeCS8
  coordinate_system RelativeCS10 = origin=(0mm, 0mm, -0.848mm) x=(1mm, 0mm, 0mm) y=(0mm, 1mm, 0mm) in RelativeCS9
  Circle50 = circle(normal=Z, centre=(-30mm, 40mm, 0.035mm), radius=1mm) in RelativeCS10
  Circle50.move(0mm, 0mm, -0.848mm) in RelativeCS10
  Circle52 = circle(normal=Z, centre=(-30mm, -20mm, 0.883mm), radius=2mm)
  Circle54 = circle(normal=Z, centre=(-30mm, -20mm, 0.883mm), radius=1mm)
  Circle52.subtract(Circle54)
  Circle52.move(0mm, 0mm, 0.035mm)
  coordinate_system RelativeCS11 = origin=(0mm, 0mm, 0mm) x=(1mm, 0mm, 0mm) y=(0mm, 1mm, 0mm)
  coordinate_system RelativeCS12 = origin=(0mm, 0mm, 0.035mm) x=(1mm, 0mm, 0mm) y=(0mm, 1mm, 0mm) in RelativeCS11
  coordinate_system RelativeCS13 = origin=(0mm, 0mm, 0.813mm) x=(1mm, 0mm, 0mm) y=(0mm, 1mm, 0mm) in RelativeCS12
  coordinate_system RelativeCS14 = origin=(0mm, 0mm, 0.035mm) x=(1mm, 0mm, 0mm) y=(0mm, 1mm, 0mm) in RelativeCS13
  coordinate_system RelativeCS15 = origin=(0mm, 0mm, -0.848mm) x=(1mm, 0mm, 0mm) y=(0mm, 1mm, 0mm) in RelativeCS14
  Circle53 = circle(normal=Z, centre=(-30mm, -20mm, 0.035mm), radius=1mm) in RelativeCS15
  Circle53.move(0mm, 0mm, -0.848mm) in RelativeCS15
  Circle55 = circle(normal=Z, centre=(-30mm, 20mm, 0.883mm), radius=2mm)
  Circle57 = circle(normal=Z, centre=(-30mm, 20mm, 0.883mm), radius=1mm)
  Circle55.subtract(Circle57)
  Circle55.move(0mm, 0mm, 0.035mm)
  coordinate_system RelativeCS16 = origin=(0mm, 0mm, 0mm) x=(1mm, 0mm, 0mm) y=(0mm, 1mm, 0mm)
  coordinate_system RelativeCS17 = origin=(0mm, 0mm, 0.035mm) x=(1mm, 0mm, 0mm) y=(0mm, 1mm, 0mm) in RelativeCS16
  coordinate_system RelativeCS18 = origin=(0mm, 0mm, 0.813mm) x=(1mm, 0mm, 0mm) y=(0mm, 1mm, 0mm) in RelativeCS17
  coordinate_system RelativeCS19 = origin=(0mm, 0mm, 0.035mm) x=(1mm, 0mm, 0mm) y=(0mm, 1mm, 0mm) in RelativeCS18
  coordinate_system RelativeCS20 = origin=(0mm, 0mm, -0.848mm) x=(1mm, 0mm, 0mm) y=(0mm, 1mm, 0mm) in RelativeCS19
  Circle56 = circle(normal=Z, centre=(-30mm, 20mm, 0.035mm), radius=1mm) in RelativeCS20
  Circle56.move(0mm, 0mm, -0.848mm) in RelativeCS20
  Circle58 = circle(normal=Z, centre=(30mm, -40mm, 0.883mm), radius=2mm)
  Circle66 = circle(normal=Z, centre=(30mm, -40mm, 0.883mm), radius=1mm)
  Circle58.subtract(Circle66)
  Circle58.move(0mm, 0mm, 0.035mm)
  coordinate_system RelativeCS21 = origin=(0mm, 0mm, 0mm) x=(1mm, 0mm, 0mm) y=(0mm, 1mm, 0mm)
  coordinate_system RelativeCS22 = origin=(0mm, 0mm, 0.035mm) x=(1mm, 0mm, 0mm) y=(0mm, 1mm, 0mm) in RelativeCS21
  coordinate_system RelativeCS23 = origin=(0mm, 0mm, 0.813mm) x=(1mm, 0mm, 0mm) y=(0mm, 1mm, 0mm) in RelativeCS22
  coordinate_system RelativeCS24 = origin=(0mm, 0mm, 0.035mm) x=(1mm, 0mm, 0mm) y=(0mm, 1mm, 0mm) in RelativeCS23
  coordinate_system RelativeCS25 = origin=(0mm, 0mm, -0.848mm) x=(1mm, 0mm, 0mm) y=(0mm, 1mm, 0mm) in RelativeCS24
  Circle59 = circle(normal=Z, centre=(30mm, -40mm, 0.035mm), radius=1mm) in RelativeCS25
  Circle59.move(0mm, 0mm, -0.848mm) in RelativeCS25
  Circle60 = circle(normal=Z, centre=(30mm, 40mm, 0.883mm), radius=2mm)
  Circle67 = circle(normal=Z, centre=(30mm, 40mm, 0.883mm), radius=1mm)
  Circle60.subtract(Circle67)
  Circle60.move(0mm, 0mm, 0.035mm)
  coordinate_system RelativeCS26 = origin=(0mm, 0mm, 0mm) x=(1mm, 0mm, 0mm) y=(0mm, 1mm, 0mm)
  coordinate_system RelativeCS27 = origin=(0mm, 0mm, 0.035mm) x=(1mm, 0mm, 0mm) y=(0mm, 1mm, 0mm) in RelativeCS26
  coordinate_system RelativeCS28 = origin=(0mm, 0mm, 0.813mm) x=(1mm, 0mm, 0mm) y=(0mm, 1mm, 0mm) in RelativeCS27
  coordinate_system RelativeCS29 = origin=(0mm, 0mm, 0.035mm) x=(1mm, 0mm, 0mm) y=(0mm, 1mm, 0mm) in RelativeCS28
  coordinate_system RelativeCS30 = origin=(0mm, 0mm, -0.848mm) x=(1mm, 0mm, 0mm) y=(0mm, 1mm, 0mm) in RelativeCS29
  Circle61 = circle(normal=Z, centre=(30mm, 40mm, 0.035mm), radius=1mm) in RelativeCS30
  Circle61.move(0mm, 0mm, -0.848mm) in RelativeCS30
  Circle62 = circle(normal=Z, centre=(30mm, -20mm, 0.883mm), radius=2mm)
  Circle68 = circle(normal=Z, centre=(30mm, -20mm, 0.883mm), radius=1mm)
  Circle62.subtract(Circle68)
  Circle62.move(0mm, 0mm, 0.035mm)
  coordinate_system RelativeCS31 = origin=(0mm, 0mm, 0mm) x=(1mm, 0mm, 0mm) y=(0mm, 1mm, 0mm)
  coordinate_system RelativeCS32 = origin=(0mm, 0mm, 0.035mm) x=(1mm, 0mm, 0mm) y=(0mm, 1mm, 0mm) in RelativeCS31
  coordinate_system RelativeCS33 = origin=(0mm, 0mm, 0.813mm) x=(1mm, 0mm, 0mm) y=(0mm, 1mm, 0mm) in RelativeCS32
  coordinate_system RelativeCS34 = origin=(0mm, 0mm, 0.035mm) x=(1mm, 0mm, 0mm) y=(0mm, 1mm, 0mm) in RelativeCS33
  coordinate_system RelativeCS35 = origin=(0mm, 0mm, -0.848mm) x=(1mm, 0mm, 0mm) y=(0mm, 1mm, 0mm) in RelativeCS34
  Circle63 = circle(normal=Z, centre=(30mm, -20mm, 0.035mm), radius=1mm) in RelativeCS35
  Circle63.move(0mm, 0mm, -0.848mm) in RelativeCS35
  Circle64 = circle(normal=Z, centre=(30mm, 20mm, 0.883mm), radius=2mm)
  Circle69 = circle(normal=Z, centre=(30mm, 20mm, 0.883mm), radius=1mm)
  Circle64.subtract(Circle69)
  Circle64.move(0mm, 0mm, 0.035mm)
  coordinate_system RelativeCS36 = origin=(0mm, 0mm, 0mm) x=(1mm, 0mm, 0mm) y=(0mm, 1mm, 0mm)
  coordinate_system RelativeCS37 = origin=(0mm, 0mm, 0.035mm) x=(1mm, 0mm, 0mm) y=(0mm, 1mm, 0mm) in RelativeCS36
  coordinate_system RelativeCS38 = origin=(0mm, 0mm, 0.813mm) x=(1mm, 0mm, 0mm) y=(0mm, 1mm, 0mm) in RelativeCS37
  coordinate_system RelativeCS39 = origin=(0mm, 0mm, 0.035mm) x=(1mm, 0mm, 0mm) y=(0mm, 1mm, 0mm) in RelativeCS38
  coordinate_system RelativeCS40 = origin=(0mm, 0mm, -0.848mm) x=(1mm, 0mm, 0mm) y=(0mm, 1mm, 0mm) in RelativeCS39
  Circle65 = circle(normal=Z, centre=(30mm, 20mm, 0.035mm), radius=1mm) in RelativeCS40
  Circle65.move(0mm, 0mm, -0.848mm) in RelativeCS40
boundaries and excitations:
  Rad1: Radiation Objects=air_box
  LumpRLC1: Lumped RLC Objects=Rectangle5 CurrentLine{(-21.345386, 41.153615, 0.883) -> (-21.794399, 41.602627, 0.883)} RLC_Type=Parallel Resistance=50ohm
  LumpRLC2: Lumped RLC Objects=Rectangle5_1 CurrentLine{(21.345386, -41.153615, -0.883) -> (21.794399, -41.602627, -0.883)} RLC_Type=Parallel Resistance=50ohm
setups:
  Setup18: HfssDriven Frequency=4GHz MaxDeltaE=0.1 MaximumPasses=20 MinimumPasses=6 MinimumConvergedPasses=2 PercentRefinement=30 BasisOrder=1 DrivenSolverType="Direct Solver"
    sweep Sweep: 0.01GHz to 5GHz step 0.01GHz; Type=Discrete
  Setup19: HfssDriven Frequency=4.2GHz MaxDeltaE=0.1 MaximumPasses=30 MinimumPasses=6 MinimumConvergedPasses=2 PercentRefinement=30 BasisOrder=1 DrivenSolverType="Direct Solver"
    sweep Sweep: 0.01GHz to 5GHz step 0.01GHz; Type=Fast
  Setup20: HfssDriven Frequency=4.5GHz MaxDeltaE=0.1 MaximumPasses=30 MinimumPasses=6 MinimumConvergedPasses=2 PercentRefinement=30 BasisOrder=1 DrivenSolverType="Direct Solver"
    sweep Sweep: 0.01GHz to 5GHz step 0.01GHz; Type=Fast
  Setup21: HfssDriven Frequency=4.5GHz MaxDeltaE=0.1 MaximumPasses=30 MinimumPasses=6 MinimumConvergedPasses=2 PercentRefinement=30 BasisOrder=1 DrivenSolverType="Direct Solver"
    sweep Sweep: 0.01GHz to 5GHz step 0.01GHz; Type=Discrete
  Setup22: HfssDriven Frequency=5GHz MaxDeltaE=0.1 MaximumPasses=30 MinimumPasses=6 MinimumConvergedPasses=2 PercentRefinement=30 BasisOrder=1 DrivenSolverType="Direct Solver"
    sweep Sweep: 0.01GHz to 5GHz step 0.01GHz; Type=Discrete
output variables:
  sdd21 = arg((S(2,1)-S(3,1)-S(2,4)+S(3,4))/2)
  sdd11 = mag((S(1,1)-S(4,1)-S(1,4)+S(4,4))/2)
  scc21 = arg((S(2,1)+S(3,1)+S(2,4)+S(3,4))/2)
  scc11 = mag((S(1,1)+S(4,1)+S(1,4)+S(4,4))/2)
  scd21 = mag((S(2,1)-S(2,4)+S(3,1)-S(3,4))/2)
  scd11 = mag((S(1,1)-S(1,4)+S(4,1)-S(4,4))/2)
  sdc11 = mag((S(1,1)+S(1,4)-S(4,1)-S(4,4))/2)
  sdc21 = mag((S(2,1)+S(2,4)-S(3,1)-S(3,2))/2)
reports:
  XY Plot 20: dB(S(1,1)), dB(S(1,2)), dB(S(2,1)), dB(S(2,2)) vs Freq on Setup18 : Sweep; markers m1 at 2.6GHz, m2 at 1.13GHz, m3 at 0.01GHz, m4 at 0.01GHz
  S Parameter Plot 1: dB(S(1,1)), dB(S(2,1)) vs Freq on Setup19 : Sweep; markers m1 at 2.59GHz, m2 at 2.05GHz, m3 at 1.21GHz, m4 at 2.83GHz
  S Parameter Plot 2: dB(S(1,1)), dB(S(1,2)), dB(S(2,1)), dB(S(2,2)) vs Freq on Setup20 : Sweep; markers m1 at 3.28GHz, m2 at 0.6GHz, m3 at 2.09GHz, m4 at 1.21GHz, m5 at 2.83GHz, m6 at 0.37GHz
  S Parameter Plot 4: dB(S(1,1)), dB(S(1,2)), dB(S(2,1)), dB(S(2,2)) vs Freq on Setup22 : Sweep

design 3-section shunt-type filter1 (HFSS, HFSS Modal Network, model units mm)
options: Save_Adaptive_support_files
geometry:
  Substrate_1 [Rogers RO4003 (tm)] = box(corner=(-35.5mm, -52mm, 0.035mm), size=((35.5*2) mm, (52*2) mm, 0.813mm))
  air_box [air] = box(corner=(-35.5mm, -52mm, -23mm), size=((35.5*2) mm, (52*2) mm, (23*2) mm))
  Substrate_2 [Rogers RO4003 (tm)] = box(corner=(-35.5mm, -52mm, -0.035mm), size=((35.5*2) mm, (52*2) mm, -0.813mm))
  Substrate_4 [copper] = box(corner=(-0.91mm, 0mm, 0.848mm), size=(1.82mm, -52mm, 0.035mm))
  Substrate_5 [copper] = box(corner=(-0.91mm, 0mm, -0.848mm), size=(1.82mm, 52mm, -0.035mm))
  Substrate_7 [copper] = box(corner=(-35.5mm, -52mm, 0mm), size=((35.5*2) mm, (52*2) mm, 0.035mm))
  Substrate_9 [copper] = box(corner=(-35.5mm, -52mm, 0mm), size=((35.5*2) mm, (52*2) mm, -0.035mm))
  Rectangle1 = rectangle(corner=(-7.52mm, -52mm, 0mm), z_size=6.504mm, x_size=15.04mm)
  Substrate_10 = box(corner=((-50.4/2) mm, (-0.44/2) mm, 0mm), size=(50.4mm, 0.44mm, 0.035mm))
  Substrate_12 = box(corner=((-50.4/2) mm, (-0.44/2) mm, 0mm), size=(50.4mm, 0.44mm, -0.035mm))
  Substrate_7.subtract(Substrate_10)
  Substrate_9.subtract(Substrate_12)
  Cylinder1 = cylinder(axis=Z, base_centre=(0mm, (100+0.635+0.65) mm, 0.848mm), radius=0.35mm, height=-0.813mm)
  Rectangle2 = rectangle(corner=(-7.52mm, 52mm, 0mm), z_size=-6.504mm, x_size=15.04mm)
  Polyline13 = polyline(z=0.883mm, xy in mm: (2.8868095, 1.610085) (5.6434672, 0.64346717) (5.6434672, 21.843467) (3.1234672, 21.843467) (2.8868095, 1.610085), closed, covered)
  Polyline13.sweep_along_vector((0mm, 0mm, -0.035mm))
  Box1 = box(corner=(3.1234672mm, 21.843467mm, 0.883mm), size=(2.52mm, -20.233382mm, -0.035mm))
  Polyline13.subtract(Box1)
  Box2 [copper] = box(corner=(3.1234672mm, 21.843467mm, 0.883mm), size=(2.52mm, -20.233382mm, -0.035mm))
  Box2.unite(Polyline13)
  Box2.rotate(axis=Z, angle=-45deg)
  Box2.move(-3.5355339mm, 3.5355339mm, -1.110223e-16mm)
  Box3 [copper] = box(corner=(-0.69mm, 100mm, 0.883mm), size=(1.38mm, -21.45mm, -0.035mm))
  Circle1 = circle(normal=Z, centre=(-10mm, 100mm, 0.883mm), radius=2.2mm)
  Circle2 = circle(normal=Z, centre=(-10mm, 100mm, 0.883mm), radius=4.95mm)
  Circle2.subtract(Circle1)
  Rectangle3 [copper] = rectangle(corner=(-10mm, (100-5) mm, 0.883mm), x_size=5mm, y_size=10mm)
  Rectangle3.intersect(Circle2)
  Rectangle3.sweep_along_vector((0mm, 0mm, -0.035mm))
  Rectangle4 = rectangle(corner=(-10mm, (100-5) mm, 0.883mm), x_size=5mm, y_size=10mm)
  Circle4 = circle(normal=Z, centre=(-10mm, 100mm, 0.883mm), radius=4.95mm)
  Circle3 = circle(normal=Z, centre=(-10mm, 100mm, 0.883mm), radius=2.2mm)
  Circle4.subtract(Circle3)
  Rectangle4.intersect(Circle4)
  Rectangle4.sweep_along_vector((0mm, 0mm, -0.035mm))
  Rectangle4.rotate(axis=Z, angle=-180deg)
  Rectangle4.move(-20mm, 192.85mm, 0mm)
  Rectangle3.unite(Rectangle4)
  Rectangle3.rotate(axis=Z, angle=-90deg)
  Rectangle3.move(-103.575mm, 68.55mm, 0mm)
  Polyline14 [copper] = polyline(z=0.883mm, xy in mm: (-14.65, 56.45) (-13.635022, 56.681449) (-13.95, 78.55) (-14.65, 78.55) (-14.65, 56.45), closed, covered)
  Polyline14.sweep_along_vector((0mm, 0mm, -0.035mm))
  Rectangle5 = rectangle(corner=(0.69mm, 100mm, 0.883mm), x_size=-1.38mm, y_size=0.635mm)
  Box4 [copper] = box(corner=((2.7/2) mm, 100.635mm, 0.883mm), size=(-2.7mm, 1.2mm, -0.035mm))
  Cylinder16 = cylinder(axis=Z, base_centre=((0-0.85) mm, (100+0.635+0.65) mm, 0.848mm), radius=0.35mm, height=-0.813mm)
  Cylinder17 = cylinder(axis=Z, base_centre=((0+0.85) mm, (100+0.635+0.65) mm, 0.848mm), radius=0.35mm, height=-0.813mm)
  [Cylinder1, Box3, Rectangle3, Polyline14, Rectangle5, Box4, Cylinder16, Cylinder17].rotate(axis=Z, angle=45deg)
  [Cylinder1, Box3, Rectangle3, Polyline14, Rectangle5, Box4, Cylinder16, Cylinder17].move(49.365292mm, -29.557063mm, -1.110223e-16mm)
  Polyline15 [copper] = polyline(z=0.883mm, xy in mm: (-0.91, 0) (-0.35596146, 0.88135735) (0.91, 0) (-0.91, 0), closed, covered)
  Polyline15.sweep_along_vector((0mm, 0mm, -0.035mm))
  Polyline16 [copper] = polyline(z=0.883mm, xy in mm: (0.91, 0) (-0.35596146, 0.88135735) (-0.35574933, 2.6327534) (0.91, 0), closed, covered)
  Polyline16.sweep_along_vector((0mm, 0mm, -0.035mm))
  Box2_1 [copper] = Box2.duplicate_around_axis(axis=Z, angle=180deg, total=2)
  Box2_1.move(1.110223e-16mm, 0mm, -1.731mm)
  Polyline16_1 [copper] = Polyline16.duplicate_around_axis(axis=Z, angle=180deg, total=2)
  Polyline15_1 [copper] = Polyline15.duplicate_around_axis(axis=Z, angle=180deg, total=2)
  Polyline15_1.move(3.4416914e-15mm, 0mm, -1.731mm)
  Polyline16_1.move(3.4416914e-15mm, 1.110223e-16mm, -1.731mm)
  Polyline14_1 [copper] = Polyline14.duplicate_around_axis(axis=Z, angle=180deg, total=2)
  Rectangle3_1 [copper] = Rectangle3.duplicate_around_axis(axis=Z, angle=180deg, total=2)
  Box3_1 [copper] = Box3.duplicate_around_axis(axis=Z, angle=180deg, total=2)
  Rectangle5_1 = Rectangle5.duplicate_around_axis(axis=Z, angle=180deg, total=2)
  Cylinder16_1 = Cylinder16.duplicate_around_axis(axis=Z, angle=180deg, total=2)
  Cylinder1_1 = Cylinder1.duplicate_around_axis(axis=Z, angle=180deg, total=2)
  Cylinder17_1 = Cylinder17.duplicate_around_axis(axis=Z, angle=180deg, total=2)
  Box4_1 [copper] = Box4.duplicate_around_axis(axis=Z, angle=180deg, total=2)
  [Polyline14_1, Rectangle3_1, Box3_1, Rectangle5_1, Box4_1].move(3.4416914e-15mm, 0mm, -1.731mm)
  Rectangle5_1.move(0mm, 0mm, -0.035mm)
  [Cylinder17_1, Cylinder1_1, Cylinder16_1].move(0mm, 0mm, -0.883mm)
  Substrate_1.subtract(Cylinder1, Cylinder16, Cylinder17)
  Cylinder18 [copper] = cylinder(axis=Z, base_centre=(0mm, (100+0.635+0.65) mm, 0.848mm), radius=0.35mm, height=-0.813mm)
  Cylinder18.rotate(axis=Z, angle=45deg)
  Cylinder18.move(49.365292mm, -29.557063mm, -1.110223e-16mm)
  Cylinder19 [copper] = cylinder(axis=Z, base_centre=((0-0.85) mm, (100+0.635+0.65) mm, 0.848mm), radius=0.35mm, height=-0.813mm)
  Cylinder19.rotate(axis=Z, angle=45deg)
  Cylinder19.move(49.365292mm, -29.557063mm, -1.110223e-16mm)
  Cylinder20 [copper] = cylinder(axis=Z, base_centre=((0+0.85) mm, (100+0.635+0.65) mm, 0.848mm), radius=0.35mm, height=-0.813mm)
  Cylinder20.rotate(axis=Z, angle=45deg)
  Cylinder20.move(49.365292mm, -29.557063mm, -1.110223e-16mm)
  Substrate_2.subtract(Cylinder1_1, Cylinder16_1, Cylinder17_1)
  Cylinder22 = cylinder(axis=Z, base_centre=((0-0.85) mm, (100+0.635+0.65) mm, 0.848mm), radius=0.35mm, height=-0.813mm)
  Cylinder22.rotate(axis=Z, angle=45deg)
  Cylinder22.move(49.365292mm, -29.557063mm, -1.110223e-16mm)
  Cylinder16_2 [copper] = Cylinder22.duplicate_around_axis(axis=Z, angle=180deg, total=2)
  Cylinder22.delete()
  Cylinder16_2.move(0mm, 0mm, -0.883mm)
  Cylinder21 = cylinder(axis=Z, base_centre=(0mm, (100+0.635+0.65) mm, 0.848mm), radius=0.35mm, height=-0.813mm)
  Cylinder21.rotate(axis=Z, angle=45deg)
  Cylinder21.move(49.365292mm, -29.557063mm, -1.110223e-16mm)
  Cylinder1_2 [copper] = Cylinder21.duplicate_around_axis(axis=Z, angle=180deg, total=2)
  Cylinder21.delete()
  Cylinder1_2.move(0mm, 0mm, -0.883mm)
  Cylinder23 = cylinder(axis=Z, base_centre=((0+0.85) mm, (100+0.635+0.65) mm, 0.848mm), radius=0.35mm, height=-0.813mm)
  Cylinder23.rotate(axis=Z, angle=45deg)
  Cylinder23.move(49.365292mm, -29.557063mm, -1.110223e-16mm)
  Cylinder17_2 [copper] = Cylinder23.duplicate_around_axis(axis=Z, angle=180deg, total=2)
  Cylinder23.delete()
  Cylinder17_2.move(0mm, 0mm, -0.883mm)
boundaries and excitations:
  Rad1: Radiation Objects=air_box
  LumpRLC1: Lumped RLC Objects=Rectangle5 CurrentLine{(-21.345386, 41.153615, 0.883) -> (-21.794399, 41.602627, 0.883)} RLC_Type=Parallel Resistance=50ohm
  LumpRLC2: Lumped RLC Objects=Rectangle5_1 CurrentLine{(21.345386, -41.153615, -0.883) -> (21.794399, -41.602627, -0.883)} RLC_Type=Parallel Resistance=50ohm
  1: Wave Port Objects=Rectangle1 WavePortType=Modal NumModes=1 Modes{Mode1{IntLine{(0, -52, 0.883) -> (0, -52, 0)} CharImp=Zpi}}
  2: Wave Port Objects=Rectangle2 WavePortType=Modal NumModes=1 Modes{Mode1{IntLine{(0, 52, -0.883) -> (0, 52, 0)} CharImp=Zpi}}
setups:
  Setup18: HfssDriven Frequency=4GHz MaxDeltaS=0.005 MaximumPasses=20 MinimumPasses=6 MinimumConvergedPasses=2 PercentRefinement=30 BasisOrder=1 PortAccuracy=2 DrivenSolverType="Direct Solver"
    sweep Sweep: 0.01GHz to 5GHz step 0.01GHz; Type=Discrete
  Setup19: HfssDriven Frequency=4.2GHz MaxDeltaS=0.005 MaximumPasses=30 MinimumPasses=6 MinimumConvergedPasses=2 PercentRefinement=30 BasisOrder=1 PortAccuracy=2 DrivenSolverType="Direct Solver"
    sweep Sweep: 0.01GHz to 5GHz step 0.01GHz; Type=Fast
  Setup20: HfssDriven Frequency=4.5GHz MaxDeltaS=0.005 MaximumPasses=30 MinimumPasses=6 MinimumConvergedPasses=2 PercentRefinement=30 BasisOrder=1 PortAccuracy=2 DrivenSolverType="Direct Solver"
    sweep Sweep: 0.01GHz to 5GHz step 0.01GHz; Type=Fast
  Setup21: HfssDriven Frequency=4.5GHz MaxDeltaS=0.005 MaximumPasses=30 MinimumPasses=6 MinimumConvergedPasses=2 PercentRefinement=30 BasisOrder=1 PortAccuracy=2 DrivenSolverType="Direct Solver"
    sweep Sweep: 0.01GHz to 5GHz step 0.01GHz; Type=Discrete
  Setup22: HfssDriven Frequency=5GHz MaxDeltaS=0.005 MaximumPasses=30 MinimumPasses=6 MinimumConvergedPasses=2 PercentRefinement=30 BasisOrder=1 PortAccuracy=2 DrivenSolverType="Direct Solver"
    sweep Sweep: 0.01GHz to 5GHz step 0.01GHz; Type=Discrete
source amplitudes:
  1:1: 1W 0deg
  2:1: 0W 0deg
output variables:
  sdd21 = arg((S(2,1)-S(3,1)-S(2,4)+S(3,4))/2)
  sdd11 = mag((S(1,1)-S(4,1)-S(1,4)+S(4,4))/2)
  scc21 = arg((S(2,1)+S(3,1)+S(2,4)+S(3,4))/2)
  scc11 = mag((S(1,1)+S(4,1)+S(1,4)+S(4,4))/2)
  scd21 = mag((S(2,1)-S(2,4)+S(3,1)-S(3,4))/2)
  scd11 = mag((S(1,1)-S(1,4)+S(4,1)-S(4,4))/2)
  sdc11 = mag((S(1,1)+S(1,4)-S(4,1)-S(4,4))/2)
  sdc21 = mag((S(2,1)+S(2,4)-S(3,1)-S(3,2))/2)
reports:
  XY Plot 20: dB(S(1,1)), dB(S(1,2)), dB(S(2,1)), dB(S(2,2)) vs Freq on Setup18 : Sweep; markers m1 at 2.6GHz, m2 at 1.13GHz, m3 at 0.01GHz, m4 at 0.01GHz
  S Parameter Plot 1: dB(S(1,1)), dB(S(2,1)) vs Freq on Setup19 : Sweep; markers m1 at 2.59GHz, m2 at 2.05GHz, m3 at 1.21GHz, m4 at 2.83GHz
  S Parameter Plot 2: dB(S(1,1)), dB(S(1,2)), dB(S(2,1)), dB(S(2,2)) vs Freq on Setup20 : Sweep; markers m1 at 3.28GHz, m2 at 0.6GHz, m3 at 2.09GHz, m4 at 1.21GHz, m5 at 2.83GHz, m6 at 0.37GHz
  S Parameter Plot 4: dB(S(1,1)), dB(S(1,2)), dB(S(2,1)), dB(S(2,2)) vs Freq on Setup22 : Sweep

design HFSSDesign13 0.6 and 2.51_9-3GHz (HFSS, HFSS Modal Network, model units mm)
options: Save_Adaptive_support_files
geometry:
  Substrate_1 [Rogers RO4003 (tm)] = box(corner=(-31.464mm, -35mm, 0.035mm), size=(62.928mm, 70mm, 0.813mm))
  air_box [air] = box(corner=(-31.464mm, -35mm, -15mm), size=((31.464*2) mm, 70mm, (15*2) mm))
  Substrate_2 [Rogers RO4003 (tm)] = box(corner=(-31.464mm, -35mm, -0.035mm), size=(62.928mm, 70mm, -0.813mm))
  Substrate_3 = box(corner=(-0.51mm, 0mm, 0.848mm), size=(0.96mm, (21.9-7.3) mm, 0.035mm))
  Substrate_4 [copper] = box(corner=(-0.91mm, 0mm, 0.848mm), size=(1.82mm, -35mm, 0.035mm))
  Substrate_5 [copper] = box(corner=(-0.91mm, 0mm, -0.848mm), size=(1.82mm, 35mm, -0.035mm))
  Substrate_7 [copper] = box(corner=(-31.464mm, -35mm, 0mm), size=(62.928mm, 70mm, 0.035mm))
  Substrate_9 [copper] = box(corner=(-31.464mm, -35mm, 0mm), size=(62.928mm, 70mm, -0.035mm))
  Rectangle1 = rectangle(corner=(-7.52mm, -35mm, 0mm), z_size=6.504mm, x_size=15.04mm)
  Substrate_10 = box(corner=((-26.2+17.47/2) mm, -0.34mm, 0mm), size=((52.4-17.47) mm, 0.68mm, 0.035mm))
  Substrate_12 = box(corner=((-26.2+17.47/2) mm, -0.34mm, 0mm), size=((52.4-17.47) mm, 0.68mm, -0.035mm))
  Substrate_7.subtract(Substrate_10)
  Substrate_9.subtract(Substrate_12)
  Substrate_14 [copper] = box(corner=(-1.3mm, (21.9+0.635) mm, 0.848mm), size=(2.6mm, 1.2mm, 0.035mm))
  Cylinder1 = cylinder(axis=Z, base_centre=(0mm, (21.9+1.3) mm, 0.848mm), radius=0.35mm, height=-0.813mm)
  Rectangle2 = rectangle(corner=(-7.52mm, 35mm, 0mm), z_size=-6.504mm, x_size=15.04mm)
  Polyline5 = polyline(z=0.883mm, xy: (0.45mm, 21.9mm) (-0.51mm, 21.9mm) (-0.51mm, (21.9+0.635) mm) (0.45mm, (21.9+0.635) mm) (0.45mm, 21.9mm), closed, covered)
  Cylinder2 = cylinder(axis=Z, base_centre=(0.8mm, (21.9+1.3) mm, 0.848mm), radius=0.35mm, height=-0.813mm)
  Cylinder3 = cylinder(axis=Z, base_centre=(-0.8mm, (21.9+1.3) mm, 0.848mm), radius=0.35mm, height=-0.813mm)
  Substrate_17 = box(corner=(-1.26mm, 0mm, 0.848mm), size=(2.52mm, (21.4-7.1) mm, 0.035mm))
  Substrate_18 = box(corner=(-0.51mm, 0mm, -0.848mm), size=(0.96mm, (-21.9+7.3) mm, -0.035mm))
  Substrate_19 [copper] = box(corner=(-1.3mm, (-21.9-0.635) mm, -0.848mm), size=(2.6mm, -1.2mm, -0.035mm))
  Cylinder7 = cylinder(axis=Z, base_centre=(0mm, (-21.9-1.3) mm, -0.848mm), radius=0.35mm, height=0.813mm)
  Polyline12 = polyline(z=-0.883mm, xy: (0.51mm, -21.9mm) (-0.45mm, -21.9mm) (-0.45mm, (-21.9-0.635) mm) (0.51mm, (-21.9-0.635) mm) (0.51mm, -21.9mm), closed, covered)
  Cylinder8 = cylinder(axis=Z, base_centre=(0.8mm, (-21.9-1.3) mm, -0.848mm), radius=0.35mm, height=0.813mm)
  Cylinder9 = cylinder(axis=Z, base_centre=(-0.8mm, (-21.9-1.3) mm, -0.848mm), radius=0.35mm, height=0.813mm)
  Substrate_20 = box(corner=(-1.26mm, 0mm, -0.848mm), size=(2.52mm, (-21.4+7.1) mm, -0.035mm))
  [Substrate_3, Cylinder1, Cylinder2, Cylinder3, Polyline5, Substrate_14].rotate(axis=Z, angle=55deg)
  [Substrate_3, Cylinder1, Cylinder2, Cylinder3, Polyline5, Substrate_14].move(-0.61747602mm, 0.41776754mm, 1.110223e-16mm)
  Substrate_17.rotate(axis=Z, angle=-45deg)
  Substrate_17.move(0.019045456mm, 0.89095454mm, 0mm)
  [Substrate_18, Substrate_19, Polyline12, Cylinder7, Cylinder8, Cylinder9].rotate(axis=Z, angle=55deg)
  [Substrate_18, Substrate_19, Polyline12, Cylinder7, Cylinder8, Cylinder9].move(0.61747602mm, -0.41776754mm, 0mm)
  Polyline13 = polyline(z=0.883mm, xy in mm: (-0.91, 0) (0.91, 0) (-0.1891632, 0.81476287) (-0.91, 0), closed, covered)
  Polyline15 = polyline(z=0.883mm, xy in mm: (-0.1891632, 1.0991632) (-0.87190909, 1.7819091) (-0.1891632, 2.464655) (-0.1891632, 1.0991632), closed, covered)
  Polyline15.sweep_along_vector((0mm, 0mm, -0.035mm))
  Polyline16 = polyline(z=0.883mm, xy in mm: (-0.1891632, 0.81476287) (-0.1891632, 2.5) (0.91, 2.5) (0.91, 0) (-0.1891632, 0.81476287), closed, covered)
  [Polyline13, Polyline16].sweep_along_vector((0mm, 0mm, -0.035mm))
  Polyline18 = polyline(z=-0.883mm, xy in mm: (0.91, 0) (0.1891632, -0.81476287) (-0.91, 0) (0.91, 0), closed, covered)
  Polyline19 = polyline(z=-0.883mm, xy in mm: (-0.91, 0) (0.1891632, -0.81476287) (0.1891632, -2.5) (-0.91, -2.5) (-0.91, 0), closed, covered)
  [Polyline19, Polyline18].sweep_along_vector((0mm, 0mm, 0.035mm))
  Substrate_17.subtract(Polyline16)
  Substrate_17.subtract(Polyline15)
  Polyline24 = polyline(z=0.883mm, xy in mm: (0.91, 0) (0.91, 2.5) (-0.15381818, 2.5) (-0.1891632, 0.81476287) (0.91, 0), closed, covered)
  Polyline24.sweep_along_vector((0mm, 0mm, -0.035mm))
  Substrate_20.rotate(axis=Z, angle=-45deg)
  Substrate_20.move(-0.019045456mm, -0.89095454mm, 0mm)
  Substrate_20.subtract(Polyline19)
  Polyline25 = polyline(z=-0.883mm, xy in mm: (0.1891632, -2.464655) (0.1891632, -1.0991632) (0.87190909, -1.7819091) (0.1891632, -2.464655), closed, covered)
  Polyline25.sweep_along_vector((0mm, 0mm, 0.035mm))
  Substrate_20.subtract(Polyline25)
  Polyline26 = polyline(z=-0.883mm, xy in mm: (-0.91, 0) (-0.91, -2.5) (0.15381818, -2.5) (0.1891632, -0.81476287) (-0.91, 0), closed, covered)
  Polyline26.sweep_along_vector((0mm, 0mm, 0.035mm))
  Substrate_18.move(0.034414586mm, 0.049149123mm, -1.110223e-16mm)
  Polyline27 = polyline(z=-0.883mm, xy in mm: (0.1891632, -0.81476287) (0.35936662, -0.78638596) (0.91, 0) (0.1891632, -0.81476287), closed, covered)
  Polyline27.sweep_along_vector((0mm, 0mm, 0.035mm))
  Polyline28 = polyline(z=0.883mm, xy in mm: (-0.35936662, 0.78638596) (-0.1891632, 0.81476287) (-0.91, 0) (-0.35936662, 0.78638596), closed, covered)
  Polyline28.sweep_along_vector((0mm, 0mm, -0.035mm))
  [Substrate_14, Cylinder1, Polyline5, Cylinder2, Cylinder3].move(5.9798099mm, -4.187108mm, -1.110223e-16mm)
  [Substrate_19, Cylinder7, Polyline12, Cylinder8, Cylinder9].move(-5.9798099mm, 4.187108mm, 0mm)
  Substrate_1.subtract(Cylinder1, Cylinder2, Cylinder3)
  Cylinder10 [copper] = cylinder(axis=Z, base_centre=(0mm, (21.9+1.3) mm, 0.848mm), radius=0.35mm, height=-0.813mm)
  Cylinder10.rotate(axis=Z, angle=55deg)
  Cylinder10.move(-0.61747602mm, 0.41776754mm, 1.110223e-16mm)
  Cylinder10.move(5.9798099mm, -4.187108mm, -1.110223e-16mm)
  Cylinder11 [copper] = cylinder(axis=Z, base_centre=(0.8mm, (21.9+1.3) mm, 0.848mm), radius=0.35mm, height=-0.813mm)
  Cylinder11.rotate(axis=Z, angle=55deg)
  Cylinder11.move(-0.61747602mm, 0.41776754mm, 1.110223e-16mm)
  Cylinder11.move(5.9798099mm, -4.187108mm, -1.110223e-16mm)
  Cylinder12 [copper] = cylinder(axis=Z, base_centre=(-0.8mm, (21.9+1.3) mm, 0.848mm), radius=0.35mm, height=-0.813mm)
  Cylinder12.rotate(axis=Z, angle=55deg)
  Cylinder12.move(-0.61747602mm, 0.41776754mm, 1.110223e-16mm)
  Cylinder12.move(5.9798099mm, -4.187108mm, -1.110223e-16mm)
  Substrate_2.subtract(Cylinder7, Cylinder8, Cylinder9)
  Cylinder13 [copper] = cylinder(axis=Z, base_centre=(0mm, (-21.9-1.3) mm, -0.848mm), radius=0.35mm, height=0.813mm)
  Cylinder13.rotate(axis=Z, angle=55deg)
  Cylinder13.move(0.61747602mm, -0.41776754mm, 0mm)
  Cylinder13.move(-5.9798099mm, 4.187108mm, 0mm)
  Cylinder14 [copper] = cylinder(axis=Z, base_centre=(0.8mm, (-21.9-1.3) mm, -0.848mm), radius=0.35mm, height=0.813mm)
  Cylinder14.rotate(axis=Z, angle=55deg)
  Cylinder14.move(0.61747602mm, -0.41776754mm, 0mm)
  Cylinder14.move(-5.9798099mm, 4.187108mm, 0mm)
  Cylinder15 [copper] = cylinder(axis=Z, base_centre=(-0.8mm, (-21.9-1.3) mm, -0.848mm), radius=0.35mm, height=0.813mm)
  Cylinder15.rotate(axis=Z, angle=55deg)
  Cylinder15.move(0.61747602mm, -0.41776754mm, 0mm)
  Cylinder15.move(-5.9798099mm, 4.187108mm, 0mm)
  Polyline29 = polyline(z=0.883mm, xy in mm: (-0.1891632, 0.81476287) (-0.35936662, 0.78638596) (-12.318986, 9.1606019) (-0.1891632, 0.81476287), closed, covered)
  Polyline29.sweep_along_vector((0mm, 0mm, -0.035mm))
  Polyline30 = polyline(z=-0.883mm, xy in mm: (0.1891632, -0.81476287) (0.35936662, -0.78638596) (12.318986, -9.1606019) (0.1891632, -0.81476287), closed, covered)
  Polyline30.sweep_along_vector((0mm, 0mm, 0.035mm))
  Substrate_5.unite(Substrate_18, Polyline30, Polyline27, Polyline18, Polyline26, Substrate_20)
  Substrate_4.unite(Polyline13, Polyline24, Polyline28, Substrate_17, Substrate_3, Polyline29)
boundaries and excitations:
  Rad1: Radiation Objects=air_box
  LumpRLC1: Lumped RLC Objects=Polyline5 CurrentLine{(-12.594303, 8.767409, 0.883) -> (-13.114465, 9.13163, 0.883)} RLC_Type=Parallel Resistance=50ohm
  LumpRLC2: Lumped RLC Objects=Polyline12 CurrentLine{(12.594303, -8.767409, -0.883) -> (13.114465, -9.13163, -0.883)} RLC_Type=Parallel Resistance=50ohm
  1: Wave Port Objects=Rectangle1 WavePortType=Modal NumModes=1 Modes{Mode1{IntLine{(0, -35, 0.883) -> (0, -35, 0)} CharImp=Zpi}}
  2: Wave Port Objects=Rectangle2 WavePortType=Modal NumModes=1 Modes{Mode1{IntLine{(0, 35, -0.883) -> (0, 35, 0)} CharImp=Zpi}}
setups:
  Setup18: HfssDriven Frequency=6GHz MaxDeltaS=0.005 MaximumPasses=30 MinimumPasses=6 MinimumConvergedPasses=2 PercentRefinement=30 BasisOrder=1 PortAccuracy=2 DrivenSolverType="Direct Solver"
    sweep Sweep: 0.01GHz to 8GHz step 0.01GHz; Type=Fast
    sweep Sweep1: 0.01GHz to 8GHz step 0.01GHz; Type=Interpolating InterpTolerance=0.5 InterpMaxSolns=250 InterpUsePortImped=false PassivityErrorTolerance=0.0001
  Setup19: HfssDriven Frequency=4GHz MaxDeltaS=0.005 MaximumPasses=30 MinimumPasses=6 MinimumConvergedPasses=2 PercentRefinement=30 BasisOrder=1 PortAccuracy=2 DrivenSolverType="Direct Solver"
    sweep Sweep: 0.01GHz to 5GHz step 0.01GHz; Type=Interpolating InterpTolerance=0.5 InterpMaxSolns=250 InterpUsePortImped=false PassivityErrorTolerance=0.0001
  Setup20: HfssDriven MultipleAdaptiveFreqsSetup{Low=0.1GHz High=5GHz} MaxDeltaS=0.005 MaximumPasses=30 MinimumPasses=6 MinimumConvergedPasses=2 PercentRefinement=30 BasisOrder=1 PortAccuracy=2 DrivenSolverType="Direct Solver"
    sweep Sweep: 0.01GHz to 5GHz step 0.01GHz; Type=Fast
  Setup21: HfssDriven Frequency=5GHz MaxDeltaS=0.005 MaximumPasses=30 MinimumPasses=6 MinimumConvergedPasses=2 PercentRefinement=30 BasisOrder=1 PortAccuracy=2 DrivenSolverType="Direct Solver"
    sweep Sweep: 0.01GHz to 5GHz step 0.01GHz; Type=Fast
source amplitudes:
  1:1: 1W 0deg
  2:1: 0W 0deg
output variables:
  sdd21 = arg((S(2,1)-S(3,1)-S(2,4)+S(3,4))/2)
  sdd11 = mag((S(1,1)-S(4,1)-S(1,4)+S(4,4))/2)
  scc21 = arg((S(2,1)+S(3,1)+S(2,4)+S(3,4))/2)
  scc11 = mag((S(1,1)+S(4,1)+S(1,4)+S(4,4))/2)
  scd21 = mag((S(2,1)-S(2,4)+S(3,1)-S(3,4))/2)
  scd11 = mag((S(1,1)-S(1,4)+S(4,1)-S(4,4))/2)
  sdc11 = mag((S(1,1)+S(1,4)-S(4,1)-S(4,4))/2)
  sdc21 = mag((S(2,1)+S(2,4)-S(3,1)-S(3,2))/2)
reports:
  XY Plot 20: dB(S(1,1)), dB(S(1,2)), dB(S(2,1)), dB(S(2,2)) vs Freq on Setup18 : Sweep; markers m1 at 2.6GHz, m2 at 1.13GHz, m3 at 0.01GHz, m4 at 0.01GHz
  S Parameter Plot 1: dB(S(1,1)), dB(S(2,1)) vs Freq on Setup19 : Sweep; markers m1 at 2.59GHz
  S Parameter Plot 2: dB(S(1,1)), dB(S(2,1)) vs Freq on Setup20 : Sweep; markers m1 at 2.6GHz
  S Parameter Plot 3: dB(S(2,1)), dB(S(1,1)) vs Freq on Setup18 : Sweep; markers m1 at 2.6GHz
  S Parameter Plot 4: dB(S(1,1)), dB(S(2,1)) vs Freq on Setup18 : Sweep1; markers m1 at 1.59GHz, m2 at 2.73GHz, m3 at 4.12GHz

design Wideband vertical transition (HFSS, HFSS Modal Network, model units mm)
options: Save_Adaptive_support_files
geometry:
  Substrate_1 [Rogers RO4003 (tm)] = box(corner=((-30/2) mm, (-35+10) mm, 0.035mm), size=(30mm, (70-20) mm, 0.813mm))
  air_box [air] = box(corner=((-30/2) mm, (-35+10) mm, -11mm), size=(30mm, (70-20) mm, (11*2) mm))
  Substrate_2 [Rogers RO4003 (tm)] = box(corner=((-30/2) mm, (-35+10) mm, -0.035mm), size=(30mm, (70-20) mm, -0.813mm))
  Substrate_3 [copper] = box(corner=((-1.91362018mm/2), 0mm, 0.848mm), size=(1.91362018mm, 6.58449979mm, 0.035mm))
  Substrate_4 [copper] = box(corner=(-0.91mm, 0mm, 0.848mm), size=(1.82mm, (-35+10) mm, 0.035mm))
  Substrate_5 [copper] = box(corner=(-0.91mm, 0mm, -0.848mm), size=(1.82mm, (35-10) mm, -0.035mm))
  Rectangle1 = rectangle(corner=(-7.52mm, (-35+10) mm, 0mm), z_size=6.504mm, x_size=15.04mm)
  Rectangle2 = rectangle(corner=(-7.52mm, (35-10) mm, 0mm), z_size=-6.504mm, x_size=15.04mm)
  Substrate_18 [copper] = box(corner=((-1.91362018mm/2), 0mm, -0.848mm), size=(1.91362018mm, -6.58449979mm, -0.035mm))
  Substrate_7 [copper] = box(corner=(-15mm, -25mm, 0mm), size=(30mm, 50mm, 0.035mm))
  StructureBSlot_top_main = box(corner=(-6.30999735mm, -0.172983509mm, -0.01mm), size=(12.6199947mm, 0.345967019mm, 0.055mm))
  Substrate_7.subtract(StructureBSlot_top_main)
  StructureBSlot_top_right_connector = box(corner=(5.96403033mm, -1.06895053mm, -0.01mm), size=(0.345967019mm, 0.895967019mm, 0.055mm))
  Substrate_7.subtract(StructureBSlot_top_right_connector)
  StructureBSlot_top_right_leg = box(corner=(4.56403033mm, -1.06895053mm, -0.01mm), size=(1.4mm, 0.345967019mm, 0.055mm))
  Substrate_7.subtract(StructureBSlot_top_right_leg)
  StructureBSlot_top_left_connector = box(corner=(-6.30999735mm, -1.06895053mm, -0.01mm), size=(0.345967019mm, 0.895967019mm, 0.055mm))
  Substrate_7.subtract(StructureBSlot_top_left_connector)
  StructureBSlot_top_left_leg = box(corner=(-5.96403033mm, -1.06895053mm, -0.01mm), size=(1.4mm, 0.345967019mm, 0.055mm))
  Substrate_7.subtract(StructureBSlot_top_left_leg)
  Substrate_9 [copper] = box(corner=(-15mm, -25mm, -0.035mm), size=(30mm, 50mm, 0.035mm))
  StructureBSlot_bottom_main = box(corner=(-6.30999735mm, -0.172983509mm, -0.045mm), size=(12.6199947mm, 0.345967019mm, 0.055mm))
  Substrate_9.subtract(StructureBSlot_bottom_main)
  StructureBSlot_bottom_right_connector = box(corner=(5.96403033mm, -1.06895053mm, -0.045mm), size=(0.345967019mm, 0.895967019mm, 0.055mm))
  Substrate_9.subtract(StructureBSlot_bottom_right_connector)
  StructureBSlot_bottom_right_leg = box(corner=(4.56403033mm, -1.06895053mm, -0.045mm), size=(1.4mm, 0.345967019mm, 0.055mm))
  Substrate_9.subtract(StructureBSlot_bottom_right_leg)
  StructureBSlot_bottom_left_connector = box(corner=(-6.30999735mm, -1.06895053mm, -0.045mm), size=(0.345967019mm, 0.895967019mm, 0.055mm))
  Substrate_9.subtract(StructureBSlot_bottom_left_connector)
  StructureBSlot_bottom_left_leg = box(corner=(-5.96403033mm, -1.06895053mm, -0.045mm), size=(1.4mm, 0.345967019mm, 0.055mm))
  Substrate_9.subtract(StructureBSlot_bottom_left_leg)
boundaries and excitations:
  Rad1: Radiation Objects=air_box
  1: Wave Port Objects=Rectangle1 WavePortType=Modal NumModes=2 Modes{Mode1{IntLine{(0, -25, 0.883) -> (0, -25, 0)} CharImp=Zpi} Mode2{CharImp=Zpi}}
  2: Wave Port Objects=Rectangle2 WavePortType=Modal NumModes=2 Modes{Mode1{IntLine{(0, 25, -0.883) -> (0, 25, 0)} CharImp=Zpi} Mode2{CharImp=Zpi}}
setups:
  Setup18: HfssDriven MultipleAdaptiveFreqsSetup{Low=0.1GHz High=15GHz} MaxDeltaS=0.005 MaximumPasses=40 MinimumPasses=6 MinimumConvergedPasses=2 PercentRefinement=30 BasisOrder=1 PortAccuracy=2 DrivenSolverType="Direct Solver"
    sweep Sweep1: 0.01GHz to 15GHz step 0.01GHz; Type=Interpolating InterpTolerance=0.5 InterpMaxSolns=250 InterpUsePortImped=false PassivityErrorTolerance=0.0001
  Setup19: HfssDriven MultipleAdaptiveFreqsSetup{Low=0.1GHz High=15GHz} MaxDeltaS=0.005 MaximumPasses=22 MinimumPasses=22 MinimumConvergedPasses=2 PercentRefinement=5 BasisOrder=1 PortAccuracy=2 DrivenSolverType="Direct Solver"
    sweep Sweep1: 0.01GHz to 15GHz step 0.01GHz; Type=Interpolating InterpTolerance=1 InterpMaxSolns=250 InterpUsePortImped=false
source amplitudes:
  1:1: 1W 0deg
  1:2, 2:1, 2:2: 0W 0deg
output variables:
  sdd21 = arg((S(2,1)-S(3,1)-S(2,4)+S(3,4))/2)
  sdd11 = mag((S(1,1)-S(4,1)-S(1,4)+S(4,4))/2)
  scc21 = arg((S(2,1)+S(3,1)+S(2,4)+S(3,4))/2)
  scc11 = mag((S(1,1)+S(4,1)+S(1,4)+S(4,4))/2)
  scd21 = mag((S(2,1)-S(2,4)+S(3,1)-S(3,4))/2)
  scd11 = mag((S(1,1)-S(1,4)+S(4,1)-S(4,4))/2)
  sdc11 = mag((S(1,1)+S(1,4)-S(4,1)-S(4,4))/2)
  sdc21 = mag((S(2,1)+S(2,4)-S(3,1)-S(3,2))/2)
